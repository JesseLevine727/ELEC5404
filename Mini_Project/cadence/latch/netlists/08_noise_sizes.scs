// Design: SAL45/STRONGARM_TB
simulator lang=spectre
global 0
parameters win=12u wtail=8u tper=2e-09 tpw=1.2e-09 trf=2e-11 tdel=2e-10 cl=5e-15 dvin=0.001 vcm=0.5 vdd=1.0
include "/CMC/kits/cadence/GPDK045/gpdk045_v_6_0/models/spectre/gpdk045.scs" section=tt

// SAL45/INV45/schematic
subckt INV45 IN OUT VDD VSS
    MP (OUT IN VDD VDD) g45p1lvt w=(700n) l=45n nf=1 m=(1)
    MN (OUT IN VSS VSS) g45n1lvt w=(250n) l=45n nf=1 m=(1)
ends INV45

// SAL45/STRONGARM/schematic
subckt STRONGARM CLK INN INP OUTN OUTP VDD VSS
    M4 (Y X Q VSS) g45n1lvt w=(2u) l=45n nf=2 m=(1)
    M3 (X Y P VSS) g45n1lvt w=(2u) l=45n nf=2 m=(1)
    M0 (TAIL CLK VSS VSS) g45n1lvt w=(wtail) l=45n nf=4 m=(1)
    M2 (Q INN TAIL VSS) g45n1lvt w=(win) l=45n nf=4 m=(1)
    M1 (P INP TAIL VSS) g45n1lvt w=(win) l=45n nf=4 m=(1)
    S4 (Q CLK VDD VDD) g45p1lvt w=(250n) l=45n nf=1 m=(1)
    S3 (P CLK VDD VDD) g45p1lvt w=(250n) l=45n nf=1 m=(1)
    S2 (Y CLK VDD VDD) g45p1lvt w=(250n) l=45n nf=1 m=(1)
    S1 (X CLK VDD VDD) g45p1lvt w=(250n) l=45n nf=1 m=(1)
    M6 (Y X VDD VDD) g45p1lvt w=(2u) l=45n nf=2 m=(1)
    M5 (X Y VDD VDD) g45p1lvt w=(2u) l=45n nf=2 m=(1)
    I_INVN (Y OUTN VDD VSS) INV45
    I_INVP (X OUTP VDD VSS) INV45
ends STRONGARM

// SAL45/STRONGARM_TB/schematic
I_SA (clk inn inp outn outp vdd 0) STRONGARM
VINN (inn 0) vsource dc=vcm-dvin/2 type=dc
VINP (inp 0) vsource dc=vcm+dvin/2 type=dc
V0 (vdd 0) vsource dc=vdd type=dc
VCLK (clk 0) vsource type=pulse val0=0 val1=vdd period=tper delay=tdel rise=trf fall=trf width=tpw
CLN (outn 0) capacitor c=cl
CLP (outp 0) capacitor c=cl
// ---- experiment 08_noise_sizes
simOpts options reltol=1e-5 vabstol=1e-9 iabstol=1e-12 temp=27 tnom=27 save=selected
save outp outn clk V0:p
a0w alter param=win value=12u
a0t alter param=wtail value=8u
det0 sweep param=dvin values=[1e-3 1e-5] {
  trd0 tran stop=2n maxstep=1p errpreset=conservative
}
noi0 sweep param=dvin values=[0.0003 0.0006 0.0009] {
  trn0 tran stop=6.002e-07 maxstep=2p errpreset=moderate noisefmax=100G noiseseed=11
}
a1w alter param=win value=12u
a1t alter param=wtail value=8u
det1 sweep param=dvin values=[1e-3 1e-5] {
  trd1 tran stop=2n maxstep=1p errpreset=conservative
}
noi1 sweep param=dvin values=[0.0003 0.0006 0.0009] {
  trn1 tran stop=6.002e-07 maxstep=2p errpreset=moderate noisefmax=200G noiseseed=12
}
a2w alter param=win value=16u
a2t alter param=wtail value=8u
det2 sweep param=dvin values=[1e-3 1e-5] {
  trd2 tran stop=2n maxstep=1p errpreset=conservative
}
noi2 sweep param=dvin values=[0.0003 0.0006 0.0009] {
  trn2 tran stop=6.002e-07 maxstep=2p errpreset=moderate noisefmax=100G noiseseed=13
}
a3w alter param=win value=24u
a3t alter param=wtail value=8u
det3 sweep param=dvin values=[1e-3 1e-5] {
  trd3 tran stop=2n maxstep=1p errpreset=conservative
}
noi3 sweep param=dvin values=[0.0003 0.0006 0.0009] {
  trn3 tran stop=6.002e-07 maxstep=2p errpreset=moderate noisefmax=100G noiseseed=14
}
a4w alter param=win value=12u
a4t alter param=wtail value=4u
det4 sweep param=dvin values=[1e-3 1e-5] {
  trd4 tran stop=2n maxstep=1p errpreset=conservative
}
noi4 sweep param=dvin values=[0.0003 0.0006 0.0009] {
  trn4 tran stop=6.002e-07 maxstep=2p errpreset=moderate noisefmax=100G noiseseed=15
}
a5w alter param=win value=24u
a5t alter param=wtail value=4u
det5 sweep param=dvin values=[1e-3 1e-5] {
  trd5 tran stop=2n maxstep=1p errpreset=conservative
}
noi5 sweep param=dvin values=[0.0003 0.0006 0.0009] {
  trn5 tran stop=6.002e-07 maxstep=2p errpreset=moderate noisefmax=100G noiseseed=16
}
