// Design: SAL45/STRONGARM_TB
simulator lang=spectre
global 0
parameters tper=2e-09 tpw=1.2e-09 trf=2e-11 tdel=2e-10 cl=5e-15 dvin=0.001 vcm=0.5 vdd=1.0
include "/CMC/kits/cadence/GPDK045/gpdk045_v_6_0/models/spectre/gpdk045.scs" section=tt

// SAL45/INV45/schematic
subckt INV45 IN OUT VDD VSS
    MP (OUT IN VDD VDD) g45p1lvt w=(700n) l=45n nf=1 m=(1)
    MN (OUT IN VSS VSS) g45n1lvt w=(250n) l=45n nf=1 m=(1)
ends INV45

// SAL45/STRONGARM/schematic
subckt STRONGARM CLK INN INP OUTN OUTP VDD VSS
    M4 (Y X Q VSS) g45n1lvt w=(2u) l=45n nf=2 m=(1)
    M3 (X Y P VSS) g45n1lvt w=(2u) l=45n nf=2 m=(1)
    M0 (TAIL CLK VSS VSS) g45n1lvt w=(8u) l=45n nf=4 m=(1)
    M2 (Q INN TAIL VSS) g45n1lvt w=(12u) l=45n nf=4 m=(1)
    M1 (P INP TAIL VSS) g45n1lvt w=(12u) l=45n nf=4 m=(1)
    S4 (Q CLK VDD VDD) g45p1lvt w=(1u) l=45n nf=1 m=(1)
    S3 (P CLK VDD VDD) g45p1lvt w=(1u) l=45n nf=1 m=(1)
    S2 (Y CLK VDD VDD) g45p1lvt w=(1u) l=45n nf=1 m=(1)
    S1 (X CLK VDD VDD) g45p1lvt w=(1u) l=45n nf=1 m=(1)
    M6 (Y X VDD VDD) g45p1lvt w=(2u) l=45n nf=2 m=(1)
    M5 (X Y VDD VDD) g45p1lvt w=(2u) l=45n nf=2 m=(1)
    I_INVN (Y OUTN VDD VSS) INV45
    I_INVP (X OUTP VDD VSS) INV45
ends STRONGARM

// SAL45/STRONGARM_TB/schematic
I_SA (clk inn inp outn outp vdd 0) STRONGARM
V0 (vdd 0) vsource dc=vdd type=dc
VCLK (clk 0) vsource type=pulse val0=0 val1=vdd period=tper delay=tdel rise=trf fall=trf width=tpw
CLN (outn 0) capacitor c=cl
CLP (outp 0) capacitor c=cl
parameters delta=10u tmid0=220p+(tpw+tper)/2
VCMS (cm 0) vsource dc=vcm
EP (inp cm dvn 0) vcvs gain=0.5
EN (inn cm dvn 0) vcvs gain=-0.5
VDV (dvn 0) vsource type=pulse val0=100m val1=-delta delay=tmid0 rise=20p fall=20p width=tper-20p period=2*tper
// ---- experiment v05_memory
simOpts options reltol=1e-6 vabstol=1e-12 iabstol=1e-13 temp=27 tnom=27 save=selected
save dvn clk outp outn I_SA.X I_SA.Y I_SA.P I_SA.Q I_SA.TAIL
a_relaxed_pw alter param=tpw value=1.2n
a_relaxed_per alter param=tper value=2n
relaxed_d sweep param=delta values=[1u 3u 10u 30u 100u 300u 1m] {
  relaxed_tr tran stop=1.62e-08 maxstep=1p errpreset=conservative
}
a_sar_pw alter param=tpw value=0.4n
a_sar_per alter param=tper value=0.6n
sar_d sweep param=delta values=[1u 3u 10u 30u 100u 300u 1m] {
  sar_tr tran stop=5e-09 maxstep=1p errpreset=conservative
}
a_sar_short_pw alter param=tpw value=0.4n
a_sar_short_per alter param=tper value=0.53n
sar_short_d sweep param=delta values=[1u 3u 10u 30u 100u 300u 1m] {
  sar_short_tr tran stop=4.44e-09 maxstep=1p errpreset=conservative
}
