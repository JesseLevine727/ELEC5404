// Design: SAL45/STRONGARM_TB
simulator lang=spectre
global 0
parameters tper=2e-09 tpw=1.2e-09 trf=2e-11 tdel=2e-10 cl=5e-15 dvin=0.001 vcm=0.5 vdd=1.0
include "/CMC/kits/cadence/GPDK045/gpdk045_v_6_0/models/spectre/gpdk045.scs" section=tt

// SAL45/INV45/schematic
subckt INV45 IN OUT VDD VSS
    MP (OUT IN VDD VDD) g45p1lvt w=(700n) l=45n nf=1 m=(1)
    MN (OUT IN VSS VSS) g45n1lvt w=(250n) l=45n nf=1 m=(1)
ends INV45

// SAL45/STRONGARM/schematic
subckt STRONGARM CLK INN INP OUTN OUTP VDD VSS
    M4 (Y X Q VSS) g45n1lvt w=(2u) l=45n nf=2 m=(1)
    M3 (X Y P VSS) g45n1lvt w=(2u) l=45n nf=2 m=(1)
    M0 (TAIL CLK VSS VSS) g45n1lvt w=(8u) l=45n nf=4 m=(1)
    M2 (Q INN TAIL VSS) g45n1lvt w=(12u) l=45n nf=4 m=(1)
    M1 (P INP TAIL VSS) g45n1lvt w=(12u) l=45n nf=4 m=(1)
    S4 (Q CLK VDD VDD) g45p1lvt w=(1u) l=45n nf=1 m=(1)
    S3 (P CLK VDD VDD) g45p1lvt w=(1u) l=45n nf=1 m=(1)
    S2 (Y CLK VDD VDD) g45p1lvt w=(1u) l=45n nf=1 m=(1)
    S1 (X CLK VDD VDD) g45p1lvt w=(1u) l=45n nf=1 m=(1)
    M6 (Y X VDD VDD) g45p1lvt w=(2u) l=45n nf=2 m=(1)
    M5 (X Y VDD VDD) g45p1lvt w=(2u) l=45n nf=2 m=(1)
    I_INVN (Y OUTN VDD VSS) INV45
    I_INVP (X OUTP VDD VSS) INV45
ends STRONGARM

// SAL45/STRONGARM_TB/schematic
I_SA (clk inn inp outn outp vdd 0) STRONGARM
VINN (inn 0) vsource dc=vcm-dvin/2 type=dc
VINP (inp 0) vsource dc=vcm+dvin/2 type=dc
V0 (vsup 0) vsource dc=vdd type=dc
VCLK (clk 0) vsource type=pulse val0=0 val1=vdd period=tper delay=tdel rise=trf fall=trf width=tpw
CLN (outn 0) capacitor c=cl
CLP (outp 0) capacitor c=cl
parameters pid=0
ahdl_include "/home/jesselevine/Desktop/StrongArm45/latch/veriloga/sa_meter.va"
// ---- experiment ds_val
MTR (clk outp outn vsup vdd) sa_meter vdd=vdd pid=pid dvin=dvin vcm=vcm file="raw/ds_val/meter.txt"
simOpts options reltol=1e-6 vabstol=1e-12 iabstol=1e-13 temp=27 tnom=27 save=none
pts paramset {
pid dvin vcm vdd temp
0 0.006020961496 0.5900927393 0.9288319225 80.63520301
1 0.001214159577 0.4846652898 1.065540519 34.78192659
2 0.008147115868 0.4055118226 1.050702622 45.74218162
3 0.00140125495 0.5576857407 0.9606389659 38.54732061
4 0.0002924685921 0.4806225973 0.9406910481 22.29663394
5 0.04065453069 0.4560817516 0.9970381949 83.36266198
6 0.2206981374 0.5449579882 1.008245371 23.53575234
7 0.0003619149425 0.5939850826 1.003213717 9.84857706
8 0.01472141247 0.5553366229 1.02260066 77.97030491
9 0.0001372995877 0.5057178527 0.9918671766 5.299714228
10 0.01698149057 0.5705265677 1.018588204 22.10828306
11 0.08324724853 0.5018991763 1.002177777 64.00756765
12 0.0003268457594 0.5639253438 1.036657381 66.90324003
13 0.0004637383015 0.5604728322 0.9382647852 6.931972476
14 0.09412996342 0.5722566992 1.075307419 40.11232615
15 0.0008972210969 0.4014183657 1.029144179 61.1922976
16 0.08042211355 0.4563755655 0.9430436334 54.34316731
17 0.06299024123 0.5927341746 0.9301049661 40.988053
18 0.1291324948 0.4845433814 1.017900412 2.081707587
19 0.02196350705 0.5838177239 1.065365066 75.26922267
20 0.01977587595 0.4491104534 1.0537034 17.99235312
21 0.07770400365 0.4125435845 1.065097563 13.98311765
22 0.002015726453 0.4633476333 1.038267407 15.17860964
23 0.002386880761 0.401164919 0.9524989426 35.80104921
24 0.0002335075803 0.5266319892 0.976084854 61.64998474
25 0.01877463077 0.4862453498 1.073464101 53.73148499
26 0.06567834065 0.4683589448 1.008733858 16.68523523
27 0.2908731974 0.4486430929 0.9513734934 6.221156153
28 0.0007877940649 0.5526257065 1.039578714 10.93722305
29 0.002033419061 0.4841842789 1.032996849 38.75396186
30 0.01094952654 0.5679369207 1.045294722 31.0256174
31 0.003623500602 0.4735399139 0.9219469328 17.27553125
32 0.0009701291962 0.4628267791 0.9626095718 49.01947588
33 0.2391574242 0.554932827 1.05822679 64.53782255
34 0.01190690056 0.5835384514 1.037926031 42.53029661
35 0.0001853658594 0.4976898454 0.9425661991 11.27918529
36 0.005749751807 0.5570170585 0.9590012886 65.34559959
37 0.006724772352 0.4298096047 1.092993549 34.13907903
38 0.001063078428 0.5693996741 0.9248920665 62.35518919
39 0.0004498724568 0.4784983552 0.9463799757 71.50437938
40 0.002271624351 0.5949385626 1.025052297 58.95794095
41 0.006507378784 0.4617936398 0.9791112842 79.97940595
42 0.0005007349738 0.5976437802 1.051661172 30.58188875
43 0.01700671905 0.4761963079 0.9762985865 42.82325077
44 0.0001143265975 0.498714312 1.094319683 24.26454445
45 0.03996175645 0.488557778 0.9418562085 76.92521852
46 0.0001144222568 0.4607017853 1.099805176 22.28247768
47 0.0895840625 0.5211366297 1.061207142 53.57700921
48 0.001824487746 0.5521577569 0.9052969098 37.9791009
49 0.001963285362 0.4954148011 0.9255241373 18.91308361
50 0.009001637717 0.4775538231 1.058331241 51.43661009
51 0.09879357371 0.5464721675 1.02036469 24.44732619
52 0.0526930164 0.4502535156 0.9150422224 81.84348917
53 0.007545437724 0.5547788595 1.005844562 51.98427708
54 0.0001311739102 0.4373587359 1.034937879 48.49799083
55 0.0003558894211 0.5904058537 0.9308707265 43.37577623
56 0.0003167491495 0.5434743452 0.9552626028 11.40138789
57 0.0001445116978 0.4349671076 0.9383597433 45.64262676
58 0.00370098136 0.5914588735 1.090830267 67.70641939
59 0.02163673054 0.5690046183 1.087750366 1.922506955
60 0.0002574341724 0.4720527769 0.9187173706 50.95958021
61 0.0008041146444 0.4528679458 0.9576655977 8.305830895
62 0.03770107267 0.5301344859 1.021301618 2.893874494
63 0.003113858729 0.537040718 0.93126933 32.7809168
64 0.0001172102868 0.4163715994 0.943290716 35.2452637
65 0.00408076679 0.5769043063 0.9633316884 1.824429484
66 0.07462404052 0.4123693871 0.9185983985 81.87044592
67 0.0416430862 0.4675708406 0.9264357683 32.87209872
68 0.001511547402 0.5748882403 0.9837506035 6.973825511
69 0.1669606274 0.5244626727 0.9233419714 9.619803604
70 0.00416971504 0.4184177931 1.026350438 52.39262224
71 0.0001292857738 0.5614845562 1.057358952 77.80120283
72 0.02141595712 0.5385724465 0.9327483309 2.030549188
73 0.0001690328176 0.592892268 1.029144273 80.48706665
74 0.001640029954 0.5510443153 0.9130797931 14.12743908
75 0.0009196576951 0.5100636503 1.011481776 42.41384845
76 0.002991653919 0.5151410321 1.093332479 38.93676264
77 0.08165629692 0.411174393 0.9771174514 47.64219771
78 0.0143525738 0.450003668 0.9798582027 80.49552434
79 0.01803568942 0.5169932497 0.9130597421 4.4349819
80 0.0005433229326 0.4275645552 1.096749986 0.2335075462
81 0.001871036722 0.4116844899 1.028002112 3.955322176
82 0.0001729293057 0.4159885011 0.9543570263 48.99043578
83 0.0631891492 0.4534383169 0.9566342113 70.08098224
84 0.03924216573 0.4253629497 1.061269787 70.65634423
85 0.000415261637 0.5253895997 0.9393487244 20.69688052
86 0.005220569861 0.5044440056 0.9958067031 45.99698953
87 0.0005510606843 0.5557160736 0.9555696824 77.57807963
88 0.006183828772 0.4607368106 0.9348767805 41.24233681
89 0.002034376547 0.5246187581 0.9996919165 3.14157433
90 0.07884452259 0.4103347878 1.065519033 69.08371969
91 0.1632305199 0.5328802082 0.9321247268 37.56399997
92 0.003372567439 0.5264665973 0.9762275065 57.43263748
93 0.0005116944251 0.4706701556 1.008662682 36.35033935
94 0.0002667083082 0.5931656242 1.03825908 70.80798161
95 0.001749582228 0.588979182 1.06248942 83.25803087
96 0.0004856951319 0.4954338953 0.9771697988 52.18107463
97 0.0007413859548 0.420094458 0.9953233174 54.3551146
98 0.0021640544 0.5974878685 0.9811977544 25.48432111
99 0.06761163322 0.4933379606 0.9546433565 24.35173708
100 0.1965058692 0.5923473496 1.029247379 23.69527802
101 0.02975201757 0.4433538964 0.9644169375 46.04759057
102 0.002482143519 0.4702047725 1.094826886 14.46752483
103 0.01362016827 0.4077082779 0.9183429474 17.84966043
104 0.2806810873 0.5452849278 1.073607619 4.206121694
105 0.02341230254 0.4879872959 0.9832839897 60.20165751
106 0.001180490173 0.5026935647 0.9521449444 33.269346
107 0.007152202127 0.4315762006 0.9552374244 35.73450194
108 0.004403541 0.5600007936 1.028590023 47.81165565
109 0.1058362402 0.439469773 0.920816607 33.46664314
110 0.0002999342838 0.5111962076 1.014728666 11.18545173
111 0.03088919316 0.5113078967 0.9846363989 77.98595073
112 0.09464786698 0.4441938328 0.9333166353 77.82059433
113 0.0003521955659 0.5514412653 0.9625034032 30.70075446
114 0.008421078887 0.5851928335 0.9004113686 13.79442342
115 0.03193476197 0.4788933059 0.957562084 81.84613094
116 0.0008280543493 0.5428333916 1.092845134 64.83511478
117 0.02928994949 0.5446413426 1.061045221 23.05316016
118 0.01510308728 0.5605771788 1.077645928 76.99590302
119 0.1389816176 0.4195267599 0.9752812175 38.7933271
120 0.1260370619 0.4838507239 0.9529824207 1.687995719
121 0.001009331057 0.5561448369 0.9040341876 14.02448388
122 0.001205798962 0.5064022144 0.9726086636 75.02437404
123 0.0005265321244 0.5123268801 1.055563501 79.01669947
124 0.1089423713 0.4271042007 1.058360016 57.40443291
125 0.00292392811 0.4051134198 0.9335962942 63.70417023
126 0.0001959272142 0.462529985 0.9510424877 63.41857624
127 0.001772125863 0.4174376482 0.9740884204 27.78053952
128 0.03112936319 0.464024444 1.03872313 45.78052854
129 0.1221109717 0.5466730346 0.9815837485 41.21730905
130 0.004355775069 0.5743404795 0.9276072343 36.05955106
131 0.007243593736 0.4872445664 1.019605694 42.40166311
132 0.002744544392 0.5373625945 0.9658644931 51.58658616
133 0.03414174504 0.4261293272 0.9652904203 80.29988723
134 0.228545751 0.5984777526 0.9085051668 70.25324536
135 0.1786764798 0.580388888 1.042988261 57.42764415
136 0.03178040747 0.5149771636 1.057684016 42.66401632
137 0.000610396568 0.418869805 1.081651145 64.16471342
138 0.0004133250263 0.5644916555 0.9600693506 54.03067263
139 0.001731357177 0.4428326173 0.9351217528 6.030776413
140 0.0001814813021 0.4138180421 0.9179837533 70.89248957
141 0.006316584853 0.425716803 1.00499893 46.12353313
142 0.005329797633 0.4412972729 0.9868795774 74.02279855
143 0.002159209518 0.5007970486 1.08604848 19.78811883
144 0.03331794433 0.4967682669 1.057473583 30.57224876
145 0.007688589381 0.4736571887 1.073229848 77.75952062
146 0.01573690109 0.5962040473 1.046411136 70.58603422
147 0.1291374447 0.4543811524 1.097335586 33.18519198
148 0.005356342068 0.4360647463 1.064295757 28.63629827
149 0.02494216933 0.443671119 0.9702726121 32.66078133
150 0.0006649214124 0.4070126884 1.054041783 80.78014636
151 0.0006119151903 0.432530273 0.9695208351 7.035110139
152 0.01816351899 0.4737105038 1.012495711 76.99724884
153 0.09904117798 0.5843353718 1.087011543 50.13464561
154 0.005579033899 0.4075230331 0.9204882623 44.53348856
155 0.09472065012 0.4865269121 0.9007458725 18.04576403
156 0.04390452614 0.4316835977 0.939915267 24.27056546
157 0.01313869342 0.567281111 0.9437789675 50.95476927
158 0.006960938066 0.4889728413 1.016084105 69.2000745
159 0.0005704693878 0.4994468302 0.9195841122 43.62519218
160 0.0562898684 0.5997117781 0.9951386108 25.21128906
161 0.0103515223 0.474350411 0.9234004778 44.58237862
162 0.06007471188 0.5782254575 1.095622238 31.25659294
163 0.0007500156715 0.4221641547 0.9872463835 68.59730862
164 0.0006544679422 0.5699132996 1.042347404 17.08013974
165 0.01572811603 0.5639384366 1.086574073 13.78825491
166 0.07215168893 0.5551698176 0.9487443281 25.03941991
167 0.2127635515 0.4724032116 0.9577952211 61.20094513
168 0.0002898213091 0.4966338633 0.9716266252 46.23883915
169 0.01251912273 0.5280214908 0.9864798116 75.38925474
170 0.08049095919 0.5866715571 0.9891811283 62.05730273
171 0.00314471632 0.4557565509 1.030377289 80.40890839
172 0.06261466019 0.4570403549 0.9456211513 65.5898642
173 0.02830200629 0.5727203493 0.9292723222 73.24273507
174 0.003193678222 0.4546690957 0.9686489325 84.44783184
175 0.2109791907 0.4167492071 0.9630376935 61.1642171
176 0.000132687425 0.4071847309 0.9089780587 73.81781083
177 0.001446865494 0.4637479666 1.058668764 27.07813478
178 0.03694993027 0.4738681457 0.9595038627 32.91425372
179 0.0003839598982 0.4150022293 1.074240289 73.81257028
180 0.004002503182 0.5376752451 1.072529923 33.21148695
181 0.02985731997 0.550958284 0.915614922 11.74377619
182 0.04064324078 0.5411297875 0.9370534964 70.27221345
183 0.06092990269 0.4665487057 0.9680563998 9.398619433
184 0.003539964854 0.421952252 1.008681428 53.08958193
185 0.01055552689 0.4143297088 1.024334089 63.93826915
186 0.0003113442173 0.5190153592 1.063811095 16.45765252
187 0.1499872821 0.5943828163 1.042328911 74.12304028
188 0.0008810923893 0.5329936774 1.085228851 3.801966763
189 0.07146714641 0.4473846334 1.060222622 54.60566092
190 0.06124459669 0.4801989961 0.9900432095 78.56527264
191 0.0001768838631 0.4312401454 1.094566482 77.62636107
192 0.0003240992553 0.5946918434 0.9530910863 75.82908363
193 0.139962978 0.4047491587 0.901942327 27.79456321
194 0.1729101452 0.5582687377 0.9773701957 72.93091917
195 0.001173355943 0.4694834805 0.9380956644 81.56184388
196 0.06227606391 0.4924849611 0.9528553141 82.10826604
197 0.002397679536 0.4421411129 0.9849312763 61.12534537
198 0.04783706161 0.4217971104 1.089186154 57.33851397
199 0.0001649321585 0.5674872875 1.094380747 71.20854959
200 0.0001081491752 0.4946177816 1.017834755 75.47988896
201 0.005599627915 0.4154647631 1.086705101 80.89754281
202 0.00490280896 0.4106885473 1.067778136 63.0421775
203 0.2382860742 0.4014627389 0.9870988899 24.12320388
204 0.0002368665189 0.5470269205 0.9682429833 3.312376825
205 0.0002914986893 0.5612000594 1.021174204 18.27930314
206 0.02631620284 0.4260809587 1.034637552 55.67842171
207 0.0001045234265 0.5023030947 1.045263086 64.47536787
208 0.02843370583 0.5770091228 1.051241568 78.3691415
209 0.002769072004 0.4068321973 0.936200683 24.46149392
210 0.0001397379953 0.4216319084 1.003755824 21.46159757
211 0.0009836492984 0.5482939053 1.070935927 73.2733837
212 0.00194399988 0.5419260147 1.070460927 12.83139091
213 0.00049813771 0.5295920586 0.953110072 16.37755807
214 0.001896323356 0.4031966494 0.9876638553 4.017945088
215 0.0007093935019 0.4435084402 0.9658890468 10.6581463
216 0.00434917692 0.5375713287 0.9677857847 78.8114236
217 0.09761435494 0.4612030271 0.9077800807 65.29629457
218 0.0006832063821 0.4664322081 1.015867045 84.90477254
219 0.001101577956 0.4937046006 1.025490177 58.08665223
220 0.0005466729009 0.5190643495 1.008821289 55.97928834
221 0.0002511067725 0.4252589032 1.095105498 69.81063299
222 0.07542531452 0.5868208816 1.092129552 33.44644023
223 0.0418777178 0.5283240185 1.011970054 57.74461258
224 0.001290353911 0.5724357436 0.9814044656 12.59518846
225 0.0001091897195 0.5278378664 0.9463263378 81.26557259
226 0.0004764903873 0.4632358816 1.096826337 44.18764272
227 0.1606909175 0.5562875348 0.9237931387 18.35859214
228 0.002219541728 0.5761912501 0.9667976565 39.36197328
229 0.004695478714 0.4649510494 1.057297057 4.660271843
230 0.0006102629771 0.5650170414 1.023268341 43.50511053
231 0.001926743908 0.4260279154 0.9913568618 83.90303044
232 0.01172721221 0.5153158701 1.098023717 75.25928732
233 0.2980829855 0.5907266679 1.03349937 25.95153646
234 0.01528023366 0.4696419672 1.062153906 11.67053919
235 0.004058164874 0.5681552044 0.9909024173 51.0865172
236 0.000219655303 0.4570209967 1.090897046 55.83986135
237 0.001857538142 0.5033762352 1.054973716 66.93497975
238 0.07567369127 0.4579285358 0.9476611878 54.27322101
239 0.006809897521 0.5129773503 0.9429229836 27.08305089
240 0.04120786355 0.4716646514 1.05149711 3.96479634
241 0.2024309922 0.4416146077 0.9956415266 78.27524652
242 0.0007609911255 0.4454768545 1.097128141 76.87656421
243 0.007090625776 0.412204389 1.020933742 21.38414594
244 0.0005548050104 0.5864286073 1.023884648 37.74335962
245 0.0001651476693 0.4743242797 1.07279663 25.72748402
246 0.001325546074 0.5213712134 0.9504281357 47.33945484
247 0.04707630593 0.4573347553 0.9945501742 48.98272361
248 0.001833780304 0.4447236749 0.9228803734 48.06612233
249 0.18178375 0.4037532405 1.073132692 81.81021437
250 0.007686612809 0.5935766917 1.040956487 46.34414268
251 0.004095003337 0.4932798014 1.036399345 19.93295635
252 0.03072815294 0.4981979474 1.034932444 79.97324879
253 0.0006482563192 0.4806451037 0.9550320258 4.477495251
254 0.01455731713 0.525704003 1.09988217 51.08728682
255 0.002384021679 0.5802317439 0.9030768642 25.73009239
256 0.04116692916 0.4322974027 0.972247195 72.17040911
257 0.001579339688 0.4485921418 1.078117654 6.580462448
258 0.09524041779 0.4630769235 0.9415569434 41.46969486
259 0.004796267554 0.5929393975 1.05050094 39.11040685
260 0.008815950752 0.4636736534 1.096544318 32.80479827
261 0.1201294619 0.5312154371 1.083228814 30.13825116
262 0.002811279345 0.4738653926 1.065408564 81.01543505
263 0.07364233511 0.4902842545 1.065819345 62.06584136
264 0.006383946145 0.4366990019 0.9475741867 59.8199617
265 0.0004909542412 0.5120691969 1.060837742 55.58133658
266 0.01318847451 0.4515466727 0.9239871937 2.882337228
267 0.0001449206003 0.4463524921 1.011536536 36.0128222
268 0.0005124797748 0.4605374277 0.9922502582 67.91008954
269 0.01908733014 0.4081811062 0.9963037992 15.80975697
270 0.0938334174 0.5769808468 1.010932942 62.59468361
271 0.024435477 0.5633669736 0.9557631489 19.4895067
272 0.03935564912 0.5918163852 0.9459635646 48.2607886
273 0.007803999524 0.4747116447 1.050047557 11.20013955
274 0.001962067596 0.4862134457 1.090599956 58.16582218
275 0.02965447421 0.5999582287 0.945355741 51.29976375
276 0.0002367842278 0.4324993348 1.039225568 70.20859135
277 0.01624595749 0.5159565789 1.058126145 81.2801808
278 0.1652543196 0.5617554014 0.9864235809 65.13839068
279 0.0006502244608 0.5808097356 0.9559468608 83.33270045
280 0.001119410195 0.4528166554 0.9672654884 41.23706109
281 0.0004967317415 0.4527446384 1.076847314 79.16218434
282 0.0003469562318 0.4882702453 0.9839692817 70.40457486
283 0.01978515149 0.4816083351 1.057739159 51.43783405
284 0.0005345322561 0.5585256312 0.9931275033 75.39079252
285 0.02056273214 0.4302292214 1.051335139 49.40248899
286 0.007640775597 0.483947511 1.032578049 5.379631999
287 0.00564794409 0.5871013438 0.9409734274 11.64613848
288 0.002675648228 0.5039020884 0.9753051669 41.13498751
289 0.02217700454 0.5585557137 0.9103182974 32.4455382
290 0.01422790575 0.4041831321 1.089839217 54.46978302
291 0.004857542228 0.4896628604 0.9294515364 5.631675262
292 0.02332404185 0.5847972279 1.0584737 1.823618468
293 0.0001366149215 0.5025316996 1.014652825 51.53944433
294 0.111184575 0.5795731576 1.097858886 28.35908393
295 0.004257786341 0.5987258626 1.040072559 4.881967777
296 0.1454190072 0.5233345473 0.9387424504 29.55696965
297 0.01019979405 0.5305532888 0.9821456951 63.27052316
298 0.007123647772 0.5949515612 1.070699213 12.75820618
299 0.0002282697709 0.5707059186 1.021546134 82.97900315
300 0.003276803322 0.4358596747 0.9073976693 65.32970135
301 0.0001951650141 0.5287806305 1.012708713 62.86330723
302 0.1914363357 0.4473042981 0.9965208185 63.88277584
303 0.0005053867936 0.4184023247 0.9276045973 79.19347879
304 0.0555811019 0.4400821701 0.903177946 54.21461599
305 0.001316161718 0.4455909227 0.9399111275 40.1391559
306 0.001548994248 0.5880434584 1.013177495 76.5107223
307 0.1640894865 0.580026498 0.9996690981 49.579613
308 0.007205812921 0.4040526961 1.089282012 12.84268001
309 0.00840297962 0.5365295714 1.057261223 46.08897027
310 0.01668268777 0.5654218719 1.028705671 56.68155432
311 0.09324865079 0.4146823334 1.00370421 2.25692202
312 0.0003360377546 0.4057012828 1.073248299 28.02774853
313 0.006486887969 0.5574515876 1.037779365 78.73673764
314 0.005047854366 0.540487563 1.073550934 9.111746958
315 0.004302722718 0.4175988517 1.011392872 26.63503445
316 0.08365933539 0.4936761739 0.9325790601 74.23722649
317 0.003025422067 0.4039422484 0.9537377717 32.56345085
318 0.0001233828181 0.428022307 0.9593017738 28.69458009
319 0.003322896822 0.4595235629 0.9641336483 39.27669586
320 0.001673835723 0.5499571896 1.056214163 1.501606927
321 0.0003661122625 0.4203638288 0.9705737401 30.28214704
322 0.04030722951 0.5459040251 1.076482947 58.05483173
323 0.01176913155 0.5988666403 1.028393343 33.10509945
324 0.001147393322 0.4071502672 1.088827676 63.97436629
325 0.002047074594 0.5750052818 1.052584706 39.53973615
326 0.2105593752 0.578479905 0.9892092445 36.29584452
327 0.0003368719608 0.4204814256 0.9714421172 18.24068739
328 0.0001731998335 0.5470959485 1.092235125 58.4280124
329 0.1429725808 0.5740733883 1.029210874 44.42209748
330 0.001755765612 0.4989952351 0.9642503903 14.62566757
331 0.005276088329 0.5322315017 1.017063024 62.71493741
332 0.001473022375 0.4000192081 0.9425319047 24.62410686
333 0.008379395499 0.4778903031 1.031534376 19.03514808
334 0.004239872999 0.4004492289 1.03726008 73.55549503
335 0.09675126776 0.5749366798 0.939226398 83.42080953
336 0.008263814109 0.4371159581 0.9182108125 6.032932558
337 0.0163988224 0.5257175891 1.057351563 55.98226462
338 0.00639778026 0.4325643292 1.046894769 0.3451662299
339 0.01976800079 0.4330621281 0.9317625001 77.0178185
340 0.1675814905 0.5440570829 0.945722655 39.89699166
341 0.001598723401 0.4235209096 0.9473632287 4.927354135
342 0.2403263038 0.4472590366 0.9774260607 20.96210827
343 0.01838638769 0.5125058648 1.053133159 0.9704435114
344 0.000514850352 0.5197475457 1.015313386 70.0772773
345 0.0001905773198 0.4742304986 0.9807512279 43.60728835
346 0.001667101367 0.5469339583 0.9208625339 5.153256646
347 0.001230458477 0.4178736717 0.9784822621 49.16658708
348 0.0001962174215 0.4919591779 1.011063528 47.98583933
349 0.00012735573 0.5546468583 1.044398882 25.24595017
350 0.004354368851 0.5478363759 1.066814946 21.05589553
351 0.04789350995 0.4848396739 1.090632098 74.66106708
352 0.001757033063 0.4719665028 0.9971671723 81.65480772
353 0.0003166925158 0.5097802533 1.029542151 61.20468133
354 0.0001711458899 0.5198630635 0.9900882069 28.85043587
355 0.2369575052 0.4212058244 1.041738356 17.3706393
356 0.1980006529 0.5000629118 0.9906775183 21.1226428
357 0.007178201915 0.5728657912 0.9144146562 55.94925265
358 0.0003232863544 0.4450140948 1.0707705 6.143082858
359 0.03500325078 0.4115706248 1.001908655 52.99817894
360 0.0003244380155 0.5604219187 0.944202156 40.43301129
361 0.0006846788411 0.5527171845 0.950228264 22.28552087
362 0.0001102402348 0.5799675196 0.9067193926 26.73984805
363 0.0177714292 0.4664171468 1.01944122 30.98801421
364 0.1147352201 0.4317958433 0.9036820862 8.474500311
365 0.006637183873 0.5184537399 1.066780564 81.14507846
366 0.002485330476 0.5647390349 0.9810339494 31.50584704
367 0.0002893304413 0.5737306767 0.9672214528 54.96874359
368 0.006284157755 0.599367505 0.9511267964 46.87738488
369 0.05567331795 0.4382161999 1.06463476 47.44442725
370 0.0002290595253 0.5936113535 0.9823703132 40.40952554
371 0.05341589116 0.5929274584 0.9491077053 11.57406651
372 0.03886150585 0.5354075016 0.9893041086 55.04658644
373 0.1918332857 0.5683821957 1.013643943 77.23327535
374 0.1493839306 0.5542311246 0.9237121911 47.74525826
375 0.01292827572 0.5758669575 1.00324598 52.07013094
376 0.03066984459 0.4167742587 0.9112685887 2.583815246
377 0.0002352230412 0.4510968293 0.9096773582 50.69793918
378 0.009770547187 0.4910582919 0.9017898707 44.1305347
379 0.0002750420052 0.4010211359 1.059245478 77.40550597
380 0.0001784291259 0.5317996299 0.9106573788 49.48604426
381 0.01477122088 0.5173504039 1.098060021 52.16036504
382 0.0003781518214 0.5865621822 0.9598022663 45.85121226
383 0.003190783228 0.5613477723 0.9168006097 31.24710302
384 0.003462387134 0.5194827656 1.081581583 25.62734163
385 0.001590277668 0.5344012255 0.9417914835 43.34001476
386 0.001293328728 0.5247500199 1.016113878 58.30240907
387 0.003119651351 0.4467292773 0.9029235053 51.13586688
388 0.0006049339686 0.4009652552 0.9750057487 23.30120106
389 0.02365680325 0.459558968 0.9735319732 61.53258051
390 0.02208597636 0.4321462513 1.017362309 79.29090557
391 0.1451867296 0.5698765209 0.9564027137 81.56507705
392 0.0004945446557 0.4803760266 0.9228268317 48.07696337
393 0.03256487846 0.5375268154 0.9014375158 83.50983913
394 0.001196579822 0.5482770517 1.085320527 66.31418796
395 0.006597364296 0.5077317343 0.9287546437 32.47620129
396 0.07243343846 0.5362366997 1.032704668 57.9215865
397 0.00164209837 0.5960406081 0.9672596554 15.90608137
398 0.02114531026 0.4338384024 1.095054626 48.91934706
399 0.0002616660581 0.4047237024 1.020241242 3.582708753
400 0.0001521774908 0.482488566 0.9896578043 70.46182198
401 0.0002817881109 0.5736664801 0.9810004245 72.50332344
402 0.0003359295016 0.4096139334 0.9871651975 18.33050438
403 0.004601959238 0.5640392958 1.077085756 7.37926023
404 0.0007833081233 0.4609721737 0.9348735137 39.69741638
405 0.0001535767283 0.4394557719 0.9130256786 38.83926048
406 0.1855461426 0.4306266299 1.077428363 26.83997779
407 0.03961537415 0.5685253534 1.021008438 61.13673329
408 0.01577472139 0.5861168874 1.055747479 35.72228217
409 0.001027227778 0.4313669321 1.00242676 19.47663386
410 0.0006555819595 0.5764096828 1.039949201 45.85449322
411 0.0854426157 0.5050761021 0.9788858702 58.26810443
412 0.01308669005 0.4417015696 0.9637162263 47.68397406
413 0.0005757614556 0.5833765845 0.9088605841 74.49075694
414 0.2554344271 0.52304805 0.9423789235 68.82912976
415 0.003424305532 0.5424897261 0.9645330478 18.82337494
416 0.207970552 0.4151494321 0.9116178028 66.53637697
417 0.0497186982 0.4622952141 0.97481184 58.4737821
418 0.01217756381 0.5296956775 0.9870665007 83.32067909
419 0.0003270182989 0.5263477024 0.9412224758 28.46299888
420 0.001082747415 0.5650266589 1.015988115 28.11741465
421 0.007282626908 0.4922478167 1.008827558 20.19101958
422 0.001998300051 0.491683556 0.916638907 1.219235964
423 0.01159160125 0.4414139965 1.060436312 2.130019923
424 0.0005971806376 0.525973574 0.9263995025 35.76024669
425 0.001089275834 0.4537061551 0.9469819756 82.95509601
426 0.0012927516 0.4235750627 1.083047359 13.45979224
427 0.03644096909 0.5317647362 1.043531061 65.73514894
428 0.000423579997 0.4074606765 0.9861466033 37.81480569
429 0.0006648865132 0.5620026903 0.9218044425 42.2883429
430 0.00687919163 0.4018721868 1.062181109 30.44525572
431 0.00391448261 0.4321652798 0.9798212675 38.46493904
432 0.01242493614 0.4070948053 0.9854874343 41.56585347
433 0.2051339132 0.5191431406 1.037142188 37.41591892
434 0.005211309506 0.5965093049 0.983016572 84.46821339
435 0.01315724571 0.583273491 1.015368856 69.84477726
436 0.07226766938 0.477145298 0.96584726 79.86485359
437 0.001396619959 0.5566893068 0.9354839336 41.574894
438 0.002060097971 0.4551917921 0.9476156596 82.03936909
439 0.02116547419 0.493003679 1.014569049 71.86781225
440 0.02256423551 0.4256789064 0.9421735879 75.76323417
441 0.008692225704 0.5180948581 0.9325984056 11.64626453
442 0.0005668629571 0.4650894007 1.011781342 31.65703292
443 0.02268994432 0.4862595005 1.002865604 80.91043856
444 0.0001402309267 0.5273678799 1.047240645 15.31003764
445 0.09819372982 0.4245683401 1.061755239 16.38039597
446 0.003036510565 0.4791076267 1.014466005 53.94259305
447 0.0001382555656 0.5629636775 1.005282236 78.07177223
448 0.0003868539615 0.4888632645 1.091095248 53.94771021
449 0.005799352855 0.4940558168 1.083017146 0.6564360583
450 0.2781049229 0.494174939 1.064350263 41.08448822
451 0.07504988026 0.4196876694 0.9851361463 65.45885884
452 0.2914146745 0.5026362997 0.9148650595 63.54075409
453 0.01795272075 0.4299321826 0.9419243843 42.66220894
454 0.0003783711775 0.5833032743 1.098154062 63.95381046
455 0.08603268411 0.4662439244 0.9213360869 61.96658234
456 0.05764315619 0.5389560269 0.935410288 2.26870198
457 0.008477375994 0.4299841393 0.9589386364 40.49447809
458 0.0007454610377 0.5865637973 0.9642818476 47.68162388
459 0.2416572987 0.5341785435 0.9771528762 64.00877086
460 0.0004709479505 0.4207954483 0.9077558199 56.76374508
461 0.01940458385 0.5341918298 1.034679309 49.53608464
462 0.1881910087 0.4919675896 0.9246650463 21.24951188
463 0.002629959357 0.5224640653 0.9715472575 37.03534216
464 0.001049119779 0.5455466882 1.069026831 28.79660711
465 0.06066177288 0.4394169521 1.094985435 30.27299312
466 0.0199428601 0.520442118 0.9164306846 49.79589786
467 0.00014525117 0.4971160156 1.00743766 80.91979694
468 0.0004298343483 0.409718927 1.02539837 26.3463945
469 0.0081917893 0.4511011661 1.038070935 10.69477248
470 0.006024110205 0.5543084167 1.078449451 27.86741791
471 0.008089115061 0.590626897 0.9276890998 70.56820629
472 0.03530401728 0.5932067058 0.9977094978 38.69784729
473 0.00787400901 0.4722383467 0.9116626052 48.33043082
474 0.002267600676 0.5010643366 1.039910283 33.47454476
475 0.000366189756 0.5661519812 1.088841577 19.95666743
476 0.01330172819 0.4754711905 1.040376694 4.647207774
477 0.1573538205 0.5709216697 0.9277416246 54.48983114
478 0.001411057136 0.4420057546 1.069497443 64.00493545
479 0.01016050327 0.5240867511 1.073944028 29.017981
480 0.005178727542 0.4458756795 0.9906204866 14.52840138
481 0.001591187365 0.5286403871 0.9553373558 55.49328539
482 0.05911593736 0.5259164955 0.9938573079 33.21248312
483 0.0001785008427 0.5532470892 1.091091116 20.50443996
484 0.02637452643 0.5205532902 1.062548359 58.05511125
485 0.0004805922702 0.4269835548 0.9673623708 15.8209097
486 0.01243183502 0.417573105 1.035056516 66.75389305
487 0.0001392414344 0.57744271 1.064061359 3.627244217
488 0.008018872357 0.4055397516 0.9953698648 6.891005813
489 0.01005513629 0.4154183409 0.9178362527 82.51506845
490 0.064826171 0.5345291315 1.057470683 18.17358315
491 0.0002290793654 0.464416361 1.052196979 64.21134713
492 0.03127371075 0.4833975622 1.001738063 62.90013613
493 0.01103801459 0.4442618141 0.9940246032 79.46165754
494 0.2196643008 0.4154916174 0.9239361952 4.931252371
495 0.005715675903 0.5796308468 1.002985717 28.27692615
496 0.115803615 0.4482907044 1.009904975 75.26516348
497 0.1072940476 0.4264353832 0.9610150305 34.66083736
498 0.04854842145 0.5373369443 1.007346068 32.03299747
499 0.0009945424274 0.5164944955 1.060763576 29.85889014
500 0.0009729768825 0.4019602939 0.9220761334 11.15633753
501 0.003182952097 0.555166902 0.9808771502 12.41363289
502 0.0003836038563 0.5905769817 1.024036846 25.20067613
503 0.08635965905 0.5894888995 1.009340874 38.50867869
504 0.002208611263 0.4750177444 1.072826692 60.52993725
505 0.1478457677 0.4066172324 0.926342015 44.60289104
506 0.01099125474 0.4860435488 1.003514443 76.61385221
507 0.009060936893 0.4524141397 0.9999683224 25.30323794
508 0.01557135318 0.5174741051 1.041605641 82.79255026
509 0.005417977286 0.4075172999 0.9989850037 43.17342618
510 0.0561708781 0.5855377948 0.9322455408 75.30270173
511 0.0003984191721 0.5180479189 0.9009336413 71.82427569
512 0.002711247942 0.4433423066 1.089232664 7.295147487
513 0.001674141598 0.4932419331 0.9528322085 30.4065657
514 0.08600016662 0.4393370731 1.011364888 18.05264142
515 0.0142386445 0.4500815779 0.9630769222 44.77718448
516 0.000750795989 0.5459267881 0.9449180049 71.17245923
517 0.02733857082 0.4258452871 1.004031047 5.626975394
518 0.0003968276951 0.4625784321 1.04157049 52.55387904
519 0.007078493894 0.4364727301 0.9594932245 58.35764893
520 0.005079571231 0.464528045 0.9138016544 3.91325877
521 0.1637694776 0.4832076817 1.07852857 20.63259572
522 0.01128515766 0.4510985027 1.076487384 19.01817325
523 0.007900520346 0.5932817001 1.0460131 47.13374925
524 0.001846950186 0.5059987031 0.9007929204 11.10955083
525 0.0009342463789 0.4093676878 0.9476466274 35.79312761
526 0.09637060586 0.5838082657 0.904129371 39.09134498
527 0.02380025043 0.5504686355 0.9318622009 0.6151110079
528 0.0007364231723 0.4628400203 0.9374325735 18.74083641
529 0.02003805126 0.44434578 0.9377693664 23.02173625
530 0.003832425021 0.4396366794 0.9991236245 79.64236387
531 0.07200573011 0.5502720543 1.088498176 78.34187662
532 0.008374907529 0.5383451549 0.9705357453 45.75772492
533 0.1589384466 0.5015239739 0.9842533827 55.9420965
534 0.004140962924 0.4190150302 0.9757880514 11.54750255
535 0.1514458727 0.5481764589 0.9878620991 6.016036299
536 0.0002471792522 0.4524831204 1.004857139 9.024980836
537 0.001827216397 0.4362173887 0.9208138976 10.26082626
538 0.0002625801673 0.5662868026 0.9360207713 9.472924953
539 0.07742642313 0.5922022053 1.046845562 6.201802951
540 0.0002952587058 0.4291047589 0.9195636657 40.8463519
541 0.0001564706563 0.5589835639 0.9821482218 16.59833557
542 0.0002106024697 0.5138292857 1.05561645 49.53438902
543 0.0006702468083 0.5605805641 1.002891755 49.7481925
544 0.1433154358 0.535060532 0.9233318266 59.03044437
545 0.001022668853 0.5580018287 1.012479642 45.95817327
546 0.0003101019738 0.4054244189 1.094963338 2.580426995
547 0.0001514045876 0.4917037197 1.08747741 46.02238684
548 0.2819170323 0.5431881872 1.064133851 69.64131516
549 0.1900846967 0.5937852973 0.9655298908 60.20939898
550 0.005858475968 0.595752473 1.018259856 34.00256364
551 0.0001310304279 0.5457895124 0.9025334347 55.12568874
552 0.0008344381602 0.5351176625 1.098363977 29.62218191
553 0.008657255869 0.511266232 0.9325748377 62.72217673
554 0.02783858127 0.5542788398 0.9441628285 5.757432886
555 0.002339021243 0.4234472415 0.9553526392 1.442419616
556 0.002504195762 0.4721354958 0.9652461117 32.77258456
557 0.0001380201741 0.4869951497 1.030742923 27.55788679
558 0.00934004169 0.5604277424 1.00502052 78.78327006
559 0.0478615164 0.5114713285 0.9167420314 39.84001857
560 0.0001317728368 0.5911312475 0.9092310463 17.68359332
561 0.0004324397656 0.5722510109 1.081534264 61.7142567
562 0.09278980906 0.4520872373 1.079075904 8.597013636
563 0.00119069276 0.5718441276 1.038177424 79.34328279
564 0.08932955133 0.4422195898 0.9836924787 84.05735161
565 0.02782117272 0.5587811125 0.9165670236 81.06886882
566 0.008202849971 0.4307199061 1.014734464 77.80793756
567 0.007820454989 0.5986242556 1.085506349 42.25960508
568 0.2304967195 0.5534662877 0.9509513643 8.371667901
569 0.00012436283 0.5042900856 1.05099219 11.11475872
570 0.0005036138566 0.5947651427 1.061400996 27.4775739
571 0.1895679814 0.4954758532 0.9507867808 29.32570804
572 0.0008838358863 0.5390206385 0.9747724122 49.11398999
573 0.01435780478 0.5009020736 0.9905379709 29.94350609
574 0.0006490995359 0.4188707994 1.039844988 1.352658764
575 0.03549678617 0.550805967 1.061208873 54.53966372
576 0.2048590307 0.4764883127 0.9917660782 24.56504825
577 0.0001085519484 0.4875661418 0.999797871 39.43148304
578 0.0001337701978 0.4319986131 0.9546301882 34.79846154
579 0.0005174578546 0.4728324596 0.9574613072 9.213554888
580 0.1114205613 0.5215675804 1.096676774 51.28520894
581 0.01377324106 0.4727785738 1.06100214 39.3191396
582 0.07292442885 0.4934375761 1.047833084 56.3116676
583 0.002393946873 0.4182136631 0.9465381831 37.44730276
584 0.004478152321 0.44298528 0.95222382 27.54566698
585 0.008022654456 0.4178822118 0.9813828699 57.96339622
586 0.08095775809 0.5032028953 1.08999588 62.51765979
587 0.05579659867 0.4270272747 1.001089323 3.018848722
588 0.02112632522 0.4650266874 1.075960563 11.11717906
589 0.0001814667662 0.4790944377 0.9316471006 46.74516436
590 0.003218273039 0.404664135 0.9486855972 13.00049954
591 0.0004177022049 0.5972953013 1.016053398 66.18514127
592 0.002186887805 0.436177434 0.9671328925 59.14486527
593 0.002723947162 0.4020368927 1.011100098 43.48808617
594 0.02340308304 0.4055839103 1.077731533 39.25093977
595 0.001799534592 0.4578016257 1.069955578 22.52688698
596 0.001104962021 0.578109924 0.993959388 4.096050787
597 0.0002650104373 0.5507559375 0.9651300938 25.88295088
598 0.001063221245 0.594544176 0.9971560971 76.14974488
599 0.0578958512 0.5575466916 1.055408581 26.00665763
}
sw sweep paramset=pts {
  tr tran stop=2n maxstep=1p errpreset=conservative outputstart=1.99n
}
