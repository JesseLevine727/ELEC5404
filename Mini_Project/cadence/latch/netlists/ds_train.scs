// Design: SAL45/STRONGARM_TB
simulator lang=spectre
global 0
parameters tper=2e-09 tpw=1.2e-09 trf=2e-11 tdel=2e-10 cl=5e-15 dvin=0.001 vcm=0.5 vdd=1.0
include "/CMC/kits/cadence/GPDK045/gpdk045_v_6_0/models/spectre/gpdk045.scs" section=tt

// SAL45/INV45/schematic
subckt INV45 IN OUT VDD VSS
    MP (OUT IN VDD VDD) g45p1lvt w=(700n) l=45n nf=1 m=(1)
    MN (OUT IN VSS VSS) g45n1lvt w=(250n) l=45n nf=1 m=(1)
ends INV45

// SAL45/STRONGARM/schematic
subckt STRONGARM CLK INN INP OUTN OUTP VDD VSS
    M4 (Y X Q VSS) g45n1lvt w=(2u) l=45n nf=2 m=(1)
    M3 (X Y P VSS) g45n1lvt w=(2u) l=45n nf=2 m=(1)
    M0 (TAIL CLK VSS VSS) g45n1lvt w=(8u) l=45n nf=4 m=(1)
    M2 (Q INN TAIL VSS) g45n1lvt w=(12u) l=45n nf=4 m=(1)
    M1 (P INP TAIL VSS) g45n1lvt w=(12u) l=45n nf=4 m=(1)
    S4 (Q CLK VDD VDD) g45p1lvt w=(1u) l=45n nf=1 m=(1)
    S3 (P CLK VDD VDD) g45p1lvt w=(1u) l=45n nf=1 m=(1)
    S2 (Y CLK VDD VDD) g45p1lvt w=(1u) l=45n nf=1 m=(1)
    S1 (X CLK VDD VDD) g45p1lvt w=(1u) l=45n nf=1 m=(1)
    M6 (Y X VDD VDD) g45p1lvt w=(2u) l=45n nf=2 m=(1)
    M5 (X Y VDD VDD) g45p1lvt w=(2u) l=45n nf=2 m=(1)
    I_INVN (Y OUTN VDD VSS) INV45
    I_INVP (X OUTP VDD VSS) INV45
ends STRONGARM

// SAL45/STRONGARM_TB/schematic
I_SA (clk inn inp outn outp vdd 0) STRONGARM
VINN (inn 0) vsource dc=vcm-dvin/2 type=dc
VINP (inp 0) vsource dc=vcm+dvin/2 type=dc
V0 (vsup 0) vsource dc=vdd type=dc
VCLK (clk 0) vsource type=pulse val0=0 val1=vdd period=tper delay=tdel rise=trf fall=trf width=tpw
CLN (outn 0) capacitor c=cl
CLP (outp 0) capacitor c=cl
parameters pid=0
ahdl_include "/home/jesselevine/Desktop/StrongArm45/latch/veriloga/sa_meter.va"
// ---- experiment ds_train
MTR (clk outp outn vsup vdd) sa_meter vdd=vdd pid=pid dvin=dvin vcm=vcm file="raw/ds_train/meter.txt"
simOpts options reltol=1e-6 vabstol=1e-12 iabstol=1e-13 temp=27 tnom=27 save=none
pts paramset {
pid dvin vcm vdd temp
0 0.01476019007 0.4548838848 1.046286603 10.63866145
1 0.0003571006691 0.5461605456 0.9918921771 83.17977861
2 0.003106336044 0.4327269141 1.079164821 41.27062212
3 0.09391860126 0.5661813529 0.9343404969 55.36911082
4 0.2416247463 0.4024326243 0.9680798942 52.18101847
5 0.001149590673 0.5986592008 1.01993523 23.78977928
6 0.0001432087965 0.484956958 0.9072750134 64.22538608
7 0.03631531761 0.5139985189 1.056200927 9.256150052
8 0.02302453716 0.4444270235 0.9184247028 28.4877039
9 0.0002320486529 0.5543224582 1.069694176 47.56641578
10 0.001983348573 0.4683546739 0.9578091048 3.168483889
11 0.1439500997 0.5329461981 1.005758382 70.06499142
12 0.05771542984 0.4980487643 1.096527705 77.34122961
13 0.004878471643 0.5006504618 0.9415473212 16.72721677
14 0.0005971297958 0.4141699195 1.029607318 59.98395416
15 0.008523108854 0.5870805001 0.9838064522 36.57310535
16 0.005557389343 0.4188262178 1.068685924 67.61613635
17 0.0005666804479 0.5791420378 0.9197602723 5.700022522
18 0.003546351038 0.4935404405 1.007423541 50.43047236
19 0.04754591974 0.5085416576 0.9555679426 25.70697939
20 0.136475619 0.4728691008 0.9468272474 39.35407051
21 0.001291949325 0.5250488991 1.091651357 57.12030543
22 0.0001913492451 0.439764622 0.9793817647 14.19543748
23 0.01675387241 0.5622670237 1.033776405 79.78967683
24 0.02631168736 0.4800948225 0.9962931791 63.21306617
25 0.0001175885929 0.5217308341 1.042093878 33.50935033
26 0.0007460250608 0.4071497655 0.929036933 75.08663801
27 0.2282101884 0.5909772754 1.084017484 18.81513412
28 0.07704145701 0.4280036697 1.01824345 1.079918044
29 0.002248457259 0.5738693815 0.9702942925 72.31893452
30 0.0003376034758 0.4597521234 1.057182415 31.55081042
31 0.009587928529 0.5384221273 0.905912823 44.33665527
32 0.01128682022 0.4361711502 0.9601368325 81.08745476
33 0.0002730510014 0.5649205541 1.001836109 15.51402689
34 0.002387002815 0.4515113531 0.914508534 55.92884073
35 0.0721654962 0.5474442445 1.072028007 38.1833793
36 0.1919393248 0.4836481886 1.025692677 24.26651152
37 0.0009131439549 0.5173963118 0.9861418108 49.01073744
38 0.0001127638194 0.4036696892 1.09885696 7.08086906
39 0.02859324248 0.5952385077 0.9376265762 69.01767278
40 0.01757423618 0.4631380221 1.075256283 43.14551482
41 0.0001771079648 0.5355611309 0.9366819587 30.38044346
42 0.0015272276 0.4495688953 1.048609754 73.6163882
43 0.110838372 0.5516815973 0.9879653282 2.398183206
44 0.04576327275 0.4168345395 0.9095966373 20.1956564
45 0.003867963827 0.5819150599 1.052272551 76.48785018
46 0.0004711642697 0.4954589242 0.9641698286 32.06920671
47 0.006724733944 0.50584183 1.022275165 61.7936555
48 0.007224184225 0.4875616122 0.9251390744 10.49173292
49 0.0007366865467 0.510356267 1.086369625 65.44015493
50 0.004641661524 0.4247790942 0.9986514241 22.53607899
51 0.0622345471 0.5772526722 1.038202123 50.90654723
52 0.1734708049 0.4416304445 1.059542188 54.03238244
53 0.001642265271 0.5563378811 0.9020225953 39.91316333
54 0.0002406172091 0.4710292302 1.014347119 84.66432411
55 0.02106889134 0.5310527978 0.9726479612 12.10251454
56 0.03414071356 0.411357704 1.009789417 35.3197293
57 0.0001525863281 0.5905152742 0.9516838187 58.70980716
58 0.000978465169 0.4759097602 1.06478349 17.96247539
59 0.2993322464 0.5222645635 0.9221078379 78.55567421
60 0.09774586284 0.4592436776 0.9754778029 71.54921268
61 0.002852890359 0.5425820967 1.036122443 4.632012723
62 0.0004254126288 0.4284892393 0.9491915962 46.23001166
63 0.0120824433 0.5696376838 1.087765706 27.13056936
64 0.01286237369 0.4057069413 0.9426569808 59.58494192
65 0.000399650054 0.5953970699 1.093926594 35.18841223
66 0.002679327954 0.4819751924 0.981989643 79.42045073
67 0.1040373052 0.5169680983 1.02993878 17.84151656
68 0.2810615583 0.4516213695 1.0707109 4.760087305
69 0.001041221749 0.5494352411 0.9157303702 70.67083542
70 0.0001624805411 0.435696115 1.003836144 27.2482857
71 0.03208200256 0.5631999718 0.9580354236 45.36199265
72 0.0197939527 0.495176862 1.020469848 65.97355107
73 0.0002562009348 0.5035345919 0.9660751874 9.375326461
74 0.001748097809 0.4175296858 1.053393608 51.45029655
75 0.1629441187 0.5837085059 0.908569519 21.40931936
76 0.06623096817 0.4473107751 0.9923121156 41.02762429
77 0.004359060682 0.5514509404 1.044167693 53.49704081
78 0.0006922978153 0.4649822952 0.9314555964 13.22732868
79 0.007694177743 0.5363063429 1.080381269 84.1186293
80 0.006311415663 0.4696004461 0.9705502467 29.50270441
81 0.0005011112452 0.5283297339 1.016351086 43.27422793
82 0.004121140901 0.4427398907 0.9032422608 1.530802404
83 0.04302183741 0.5592795748 1.058222671 73.73474306
84 0.1180608267 0.4221066741 1.04245221 76.35719158
85 0.001435344884 0.5758737676 0.9945029059 21.07144996
86 0.0001662580254 0.4905526072 1.081436805 61.67335514
87 0.0186952427 0.5115173047 0.9301673589 32.93464202
88 0.03041582571 0.4308934892 1.092894722 14.97802615
89 0.0001058415193 0.5709917959 0.9439688351 82.20125757
90 0.0008586099045 0.4563736055 1.03167788 37.63702538
91 0.2045113744 0.5417884113 0.9798225172 57.05299671
92 0.06783703696 0.4772168525 0.9210842703 47.89369214
93 0.002542652784 0.524621032 1.065908622 24.79926977
94 0.0002905178533 0.410515671 0.9535871491 67.8902743
95 0.01059621458 0.5875991419 1.007981548 7.623980488
96 0.01019906524 0.4869225146 1.051071982 34.29435155
97 0.0003168783553 0.5141342137 0.9124978933 63.01237226
98 0.002114179726 0.4006878909 1.024379912 19.61053411
99 0.08208779954 0.5982080782 0.9637352511 74.87554532
100 0.2145225345 0.4329086736 0.9353641357 72.52287093
101 0.0007946724661 0.5681952646 1.078039808 0.2981593134
102 0.0001251104611 0.4544805391 0.9899889655 44.55099045
103 0.02470172118 0.5444628246 1.048094543 30.75865292
104 0.01572410169 0.4139626045 0.9859042862 6.162740397
105 0.000203510826 0.5847991811 1.027603423 66.40830379
106 0.001376516986 0.4988186995 0.9403277276 26.15930356
107 0.1283003935 0.5024698686 1.097847341 49.23303351
108 0.05064422983 0.4660217589 1.001508415 58.33008348
109 0.003332999591 0.5326895744 0.9619576948 38.89329813
110 0.0005319633569 0.4461965553 1.074627068 80.98906118
111 0.005911864027 0.555041757 0.9133965379 13.74505881
112 0.008007339791 0.4383618047 1.035581841 46.78401885
113 0.0006358023743 0.5596187547 0.9774764778 28.69100178
114 0.005192862534 0.4740044601 1.090530372 69.27219571
115 0.05421317621 0.5280653341 0.9478544852 3.382180543
116 0.1531941432 0.4908421014 0.9512212748 16.52586439
117 0.001862597933 0.5070880057 1.011865673 78.12557204
118 0.0002180663488 0.4217912519 0.9249867065 36.36135419
119 0.02452244049 0.5802282866 1.063561058 60.77869537
120 0.03865940517 0.4621334583 0.9008824896 82.71966533
121 0.0001345358902 0.5397044962 1.0621129 11.84909767
122 0.001079655152 0.4251107363 0.9744465791 54.91939125
123 0.2571776106 0.5730040066 1.013997418 42.47066462
124 0.0881861935 0.408479725 1.085334662 22.58258556
125 0.003305577417 0.5934054393 0.9278152157 52.64437424
126 0.0003802553754 0.4792756986 1.040093963 8.059350043
127 0.01387010628 0.5188864389 0.9983946592 64.67834814
128 0.01355895273 0.4485809671 1.082454875 2.808510363
129 0.0003957430147 0.5527182598 0.9305995394 70.05273692
130 0.003176599724 0.4637105893 1.043656485 27.95782503
131 0.09022092928 0.5350374857 0.9947305709 47.39462938
132 0.2515291791 0.496442464 0.904350407 60.21147091
133 0.001124169546 0.504809553 1.058744833 37.13804367
134 0.0001292243805 0.4162655978 0.9718567096 77.3858685
135 0.03953238424 0.5824350826 1.016681034 17.14040771
136 0.02355141118 0.4505447838 0.9540055508 41.73699912
137 0.0002229633267 0.5483618857 1.008985935 55.52919353
138 0.001821466869 0.4367711866 0.9213226659 11.2749438
139 0.159490882 0.5642717894 1.067123532 83.49939323
140 0.05209151118 0.4046379736 1.032213821 63.93815585
141 0.005312029381 0.5943191484 0.9809443476 8.673085114
142 0.0006214632419 0.4830456741 1.09321394 52.0766661
143 0.008332457308 0.5180475576 0.9452646634 23.35846174
144 0.006063110474 0.4753650969 1.004195798 75.65543661
145 0.0005124614776 0.5227602988 0.9593716877 19.03621686
146 0.003460260622 0.4123659126 1.071256759 63.6223354
147 0.04938692462 0.5894583372 0.9168621188 33.56052519
148 0.1313890247 0.4290371437 0.9822440604 31.53469501
149 0.001324101072 0.5691387044 1.031169712 43.98311639
150 0.0002115928612 0.458231465 0.9431097148 0.9120527096
151 0.01535634286 0.5436430406 1.094965313 71.78252032
152 0.02567956442 0.424152036 0.9327780809 49.84348571
153 0.0001221694234 0.5779284647 1.080727239 25.42628513
154 0.000813703548 0.4885057313 0.9934545942 67.18867908
155 0.206328597 0.5094610699 1.044724187 5.589236142
156 0.08521167602 0.4716534259 1.054638319 14.35944127
157 0.002061440761 0.5303798649 0.9088376198 80.2495185
158 0.0003249455271 0.4406884249 1.021497837 39.66982423
159 0.0098239653 0.5572309816 0.966517286 57.76302242
160 0.01034775706 0.4672967322 0.9236702297 73.14097212
161 0.0003019998919 0.5339552147 1.063221096 2.249733564
162 0.002445682301 0.444923096 0.9501214251 42.51835135
163 0.06945736987 0.5537776545 1.011351809 30.04911596
164 0.1994219228 0.4152299607 1.08932829 32.3447228
165 0.000891230021 0.5860693868 0.9476290133 62.38584058
166 0.0001019551329 0.4975498293 1.03455986 20.31164059
167 0.0311882583 0.5011981251 0.9770403869 76.91012992
168 0.01801097379 0.4318307189 1.039764732 56.29793313
169 0.0001705011004 0.5671262853 0.9970888177 38.18392093
170 0.00139979602 0.4555600077 1.084807019 81.60829456
171 0.1225611395 0.5455333417 0.9267016826 15.69744638
172 0.04138614677 0.4858491492 0.9742103772 6.864984119
173 0.004220092629 0.5130575934 1.012784702 68.44369663
174 0.0004894210956 0.4017597424 0.9004601782 24.21015848
175 0.006561661176 0.5992831606 1.061104604 48.60666665
176 0.007866479554 0.4066266473 0.9895277442 18.56109511
177 0.0006649250324 0.5915491307 1.047047337 78.82732939
178 0.00453795449 0.4811302902 0.9351195415 35.7354737
179 0.06477237827 0.5207442854 1.076818699 58.82971242
180 0.1666732315 0.4602727635 1.023837773 46.07512801
181 0.001679787762 0.537852753 0.9626072222 26.65901355
182 0.0002665870009 0.4269699171 1.050709945 71.22442115
183 0.01934872292 0.5748542121 0.9111592455 4.000927545
184 0.03338664542 0.4928921977 1.073590591 21.95556751
185 0.0001588452347 0.5091409754 0.9129459511 50.69458336
186 0.001065181104 0.4197426695 1.000273526 10.09409676
187 0.2701115723 0.5781768547 0.9616994165 65.37994098
188 0.1083201798 0.4404164903 0.939188968 84.67140171
189 0.002620641848 0.5616640834 1.097294566 12.46768523
190 0.0004086496546 0.4719482606 0.9845794171 54.20936792
191 0.01235531726 0.5260184675 1.027255069 40.4378634
192 0.01160958967 0.4993205056 0.9782599332 51.47958458
193 0.0004351750828 0.5019193312 1.033240463 21.7548736
194 0.002788549655 0.412899716 0.945531418 66.17534098
195 0.1017145832 0.5858131446 1.091332138 9.883004078
196 0.2874794137 0.4456911238 1.006419156 12.67162164
197 0.001000437942 0.5555959169 0.9551495427 83.88964298
198 0.0001492168205 0.4670890357 1.067471015 40.65219858
199 0.03554399931 0.5316712255 0.9195218785 53.41721042
200 0.02060615203 0.401357541 1.056660255 79.29004726
201 0.0002505379039 0.597587347 0.9048046779 17.35326255
202 0.001577428239 0.486033579 1.017913503 59.28203659
203 0.1773879987 0.5150718866 0.9689878307 34.53803485
204 0.06083841499 0.453813367 0.9286047507 27.86879161
205 0.004830714418 0.5450810747 1.082999412 45.61435563
206 0.0007079423609 0.4337958941 0.9960655123 5.200311891
207 0.007390869117 0.5672593098 1.040889601 70.77404248
208 0.006980645765 0.4261534635 0.9070069108 37.40152399
209 0.0004594109095 0.5720101984 1.054956215 56.50123101
210 0.00396643546 0.4616038674 0.9676377937 14.90465066
211 0.04408019685 0.5402828243 1.01890724 81.82199121
212 0.1152260239 0.4782369753 1.078818853 68.24234425
213 0.001491326254 0.5198762402 0.9330180135 7.649326553
214 0.0001813494055 0.4090060748 1.04573011 48.39491549
215 0.01690296781 0.5928303553 0.9907496996 25.00489969
216 0.02928158006 0.4749159651 1.028376388 1.789620291
217 0.000108469925 0.5271050978 0.9835520366 74.35140833
218 0.0009494076846 0.4377192955 1.095488988 29.5993964
219 0.1874502046 0.5602123389 0.941094589 43.71839385
220 0.07401174551 0.4208776474 0.9564728396 61.17864687
221 0.002299494831 0.5811906194 1.005398727 32.80807856
222 0.0002834766708 0.4914874731 0.9172929531 75.71332991
223 0.01100661104 0.506491562 1.069148316 20.76460265
224 0.009223395402 0.4181079635 1.015559834 26.30141989
225 0.0003457095921 0.5831791501 0.972884162 49.71216864
226 0.002196004232 0.4941839624 1.060550483 6.454012659
227 0.08009612492 0.5045762258 0.9024449056 67.06772025
228 0.2198574144 0.46440688 0.9999572674 80.37759308
229 0.0007650643843 0.5368328391 1.038531356 13.48106402
230 0.0001146763026 0.4483015751 0.9262526093 57.88073875
231 0.02731465189 0.5504114032 1.08689727 38.80180522
232 0.01633693704 0.4825687315 0.9494170692 19.569613
233 0.0001986189431 0.5163258309 1.088967789 74.53903015
234 0.00124451034 0.4047476085 0.9759138949 34.10427451
235 0.1399415192 0.5963074747 1.037144425 62.49557577
236 0.04643107433 0.4350993348 1.06512345 45.09757735
237 0.003686512267 0.5638454832 0.9234243128 30.99935337
238 0.0005450686585 0.4525847062 1.01030328 72.90733445
239 0.005690131297 0.5485208293 0.9527836666 0.3663578955
240 0.008873977293 0.4573890505 1.099409733 54.65145449
241 0.0005840506866 0.540724238 0.938765334 41.86571223
242 0.004988328493 0.4303423285 1.026041029 82.63201243
243 0.0554401904 0.5714940285 0.987466678 11.39329867
244 0.1498039571 0.4094985109 0.9149591219 8.542426513
245 0.001938973538 0.5886650333 1.073064485 64.8139494
246 0.0002373882802 0.4777704911 0.9603951119 23.23816138
247 0.02212751531 0.5241163183 1.003070999 52.94210141
248 0.0371464241 0.4436790384 0.9652978593 69.51673618
249 0.0001376126568 0.5583893491 1.022817306 3.922313168
250 0.001196193644 0.4689790985 0.910935287 46.84827546
251 0.2361898272 0.5289998159 1.052634591 29.08198101
252 0.09602179482 0.4896178478 1.049656959 36.02099838
253 0.002983514536 0.5124031451 0.9884265484 60.74422916
254 0.0003717559133 0.4227243964 1.076477391 16.01300923
255 0.01443512968 0.5752073081 0.9369265517 77.92897993
256 0.01408001778 0.4230850235 0.9734336726 38.5433001
257 0.0003626101568 0.5756629338 1.015132783 57.97483936
258 0.002964673139 0.4892064733 0.9027991038 13.39018058
259 0.09541531423 0.5120928712 1.060318744 80.63934576
260 0.2379244353 0.4693901839 1.038982822 66.81085158
261 0.001204977474 0.5293105636 0.9994321704 6.549739577
262 0.0001409451629 0.4433179375 1.087153423 49.61966902
263 0.03804594723 0.5579340125 0.9259228248 26.56156652
264 0.02196627633 0.4773956424 1.088540355 0.6063706707
265 0.0002356587126 0.5236472577 0.9499661973 72.83624541
266 0.001893121266 0.4099202685 1.036912303 31.07239298
267 0.1462615706 0.5889864771 0.9762677105 44.85948474
268 0.05683823042 0.4299202878 0.9228995992 62.73462086
269 0.005114124556 0.5711730646 1.065575298 34.03222792
270 0.0005877647409 0.4577634195 0.9524542654 74.6130577
271 0.008930416459 0.5411935817 1.010559816 19.3324982
272 0.005822235137 0.4529911075 0.9384111373 53.0355486
273 0.0005577225997 0.5488330187 1.099641473 22.97901267
274 0.003717216749 0.4347398425 0.9869171688 65.0750588
275 0.04681774873 0.563385677 1.026468083 8.450889345
276 0.1386506814 0.4051068177 1.07280833 11.48838231
277 0.001233029591 0.5967677608 0.9152889049 82.37449003
278 0.0001943016178 0.4821618505 1.002619532 42.12520545
279 0.015981811 0.5160139246 0.9609202074 54.55831127
280 0.02756905697 0.4478809522 1.023049426 77.8585443
281 0.0001157444948 0.5500857789 0.9649440423 16.2536656
282 0.0007820608946 0.4647767555 1.053062024 60.50677982
283 0.2247419318 0.5373038152 0.9103861574 36.0946917
284 0.07827848063 0.4938137978 0.9887559511 29.0105777
285 0.002146171824 0.5041057235 1.049400424 47.08797427
286 0.0003428553196 0.4185281126 0.9374512669 3.685851777
287 0.00914725286 0.5835050635 1.076025544 69.59140731
288 0.01110913561 0.4917977551 1.032983928 53.17785105
289 0.0002861169438 0.5069029223 0.9785893358 40.72393121
290 0.002350582206 0.4204220373 1.090880291 83.81465266
291 0.0756559727 0.5808299826 0.9460561331 12.90777398
292 0.183196521 0.4381746225 0.9547957256 9.642008264
293 0.000927862532 0.5605734555 1.006651276 66.2454473
294 0.0001075744688 0.4746052032 0.9189727489 21.68149946
295 0.02903982249 0.5266940206 1.067898448 51.71734297
296 0.01729537606 0.4086846467 0.9051344609 71.03189419
297 0.0001855596636 0.592408588 1.056404101 5.105567696
298 0.001503745859 0.4787060441 0.9695129262 45.7071898
299 0.11618573 0.5202510748 1.017462036 27.6089792
300 0.04367355333 0.4611345096 1.083231152 34.79685424
301 0.003929848451 0.5399084635 0.928250554 59.18824994
302 0.0004494243987 0.4264744177 1.041316655 17.44510876
303 0.006828909592 0.5724322548 0.9955160031 79.02925705
304 0.007337020377 0.434255716 1.055408063 25.07728573
305 0.000702783741 0.5676187925 0.9064821972 48.15619971
306 0.004716483546 0.4535011858 1.019163776 7.886122167
307 0.05939972441 0.5446746593 0.9673083926 68.16800765
308 0.1818613779 0.4863454711 0.9335671416 81.8927408
309 0.00161720643 0.5154787758 1.078391418 14.66430857
310 0.0002521313515 0.4008972453 0.9911035152 56.73964281
311 0.02073718861 0.5972281534 1.045497988 37.32879344
312 0.03466956432 0.4666180678 0.9830269396 20.66920504
313 0.0001455460026 0.5313013358 1.028827854 75.97053803
314 0.0009941190739 0.4460167637 0.9407648046 32.54762289
315 0.2856639414 0.5560165301 1.095745141 61.27082731
316 0.1024614917 0.412573793 1.004971675 43.62396393
317 0.002809029034 0.5853930112 0.9570223503 29.85756206
318 0.0004457130974 0.4997909937 1.068916577 74.08996471
319 0.01189073443 0.502289504 0.9176471513 1.880822917
320 0.01266733005 0.4722742693 1.062769624 76.83855957
321 0.0004189689969 0.526438712 0.9241953207 20.55148617
322 0.002637379769 0.4399458926 1.01109565 62.14920203
323 0.1090119168 0.5612938235 0.9504512036 32.41955084
324 0.2681343716 0.4202135503 0.9470795086 29.97852343
325 0.001057383017 0.5785466349 1.089755348 42.75918488
326 0.0001550849085 0.4925666688 0.9766861947 2.012137459
327 0.03259625631 0.5087204479 1.034791605 73.21483248
328 0.0194913241 0.4266581062 0.9976135254 48.70189706
329 0.0002685520305 0.5744474264 1.039312877 23.95246906
330 0.00172052398 0.4607329542 0.9270310778 68.70334676
331 0.170715348 0.5382118668 1.084550476 6.771663739
332 0.06317719258 0.4806703886 1.013212142 15.79107074
333 0.00442620003 0.5203846976 0.9736612551 81.34898895
334 0.0006607026062 0.4069389321 1.061336732 38.44519736
335 0.007816532951 0.5919556273 0.9001063686 56.2062492
336 0.006412590459 0.4022291815 1.047303497 4.240129855
337 0.0004783017474 0.599657625 0.9891979672 71.15219708
338 0.004185110464 0.4855280899 1.077270172 26.73318819
339 0.04104304062 0.5126354573 0.934594452 45.83784587
340 0.1237060855 0.4558813561 0.962961413 59.06989255
341 0.001412871272 0.545955004 1.023606026 35.66423758
342 0.0001742950669 0.4313617537 0.9117087487 78.90054647
343 0.0184117347 0.5667515319 1.050282886 18.32284528
344 0.03089948183 0.497094588 0.9126165545 40.18081725
345 0.0001010112139 0.5008371195 1.073847132 54.30525206
346 0.0008718334938 0.415540613 0.9611747073 12.37501826
347 0.1950819327 0.5864803769 1.00072538 84.93169542
348 0.07107228558 0.4446127268 1.09706244 65.12128878
349 0.002502548037 0.5533661846 0.9395427791 10.18836472
350 0.0003045230662 0.4677524533 1.02682763 50.6035427
351 0.01043422087 0.5343159372 0.9851285407 22.21749767
352 0.009733012965 0.4410586931 0.9309533505 17.04582057
353 0.0003219368203 0.5577015651 1.082222749 77.64421165
354 0.002016577989 0.4712331971 0.9952796945 36.87645297
355 0.08335714603 0.5300538465 1.043229046 60.30284089
356 0.2111260362 0.4889262492 1.059001373 47.29906443
357 0.0008326225536 0.5097866144 0.9040210104 28.21518023
358 0.0001231902506 0.4237822417 1.017132887 69.79210376
359 0.02589411345 0.5774575921 0.9713320004 2.900848021
360 0.01500745658 0.4578723667 1.008754188 23.42938881
361 0.000206785795 0.5431828402 0.9543597415 51.83616679
362 0.001313123756 0.4294439375 1.066696473 8.911664258
363 0.1302998884 0.5694505012 0.9218721692 63.86527821
364 0.04984824082 0.4119594019 0.9806145705 83.57192635
365 0.003492585703 0.5891460607 1.032469981 11.03606068
366 0.0005238642062 0.4757246749 0.9447395738 55.76614636
367 0.006198026141 0.5232202161 1.093665413 41.66248504
368 0.008393876124 0.4834678259 0.9588225655 72.04150674
369 0.0006260434797 0.5183686072 1.004623238 0.8181192959
370 0.00544085552 0.4042635174 0.9165083092 44.07513977
371 0.05335477105 0.5938496951 1.071488887 31.27374789
372 0.1555631568 0.4371459259 1.030717857 33.8185338
373 0.001776608636 0.5647407629 0.9827687681 63.52741404
374 0.0002215476733 0.4501231119 1.094708771 19.12919779
375 0.02340185363 0.548040553 0.94343911 75.39545717
376 0.04053066895 0.4158546159 1.081154296 57.52187984
377 0.0001324877213 0.5821244162 0.9322285762 39.74009758
378 0.001131348504 0.4968034852 1.044955932 80.17598746
379 0.2531356922 0.5052647846 0.9931004019 14.59737683
380 0.08956043329 0.4633498572 0.9093627108 5.349699608
381 0.003153347109 0.5345817802 1.054186848 67.26056861
382 0.0003863742582 0.4489924228 0.9668470645 25.35112777
383 0.01323797349 0.5530286372 1.021241678 50.07978482
384 0.0137686307 0.4796016119 0.9119487656 30.68530411
385 0.0003774729982 0.519306588 1.051499417 44.78874377
386 0.003227312468 0.4080092227 0.9633814359 0.0571584329
387 0.08609816288 0.5930352747 1.024612034 72.59300258
388 0.2636711889 0.4255817125 1.07758796 74.8005702
389 0.001106914715 0.5733738821 0.9358888498 19.84665099
390 0.0001353956838 0.461807834 1.047838007 62.77297743
391 0.03890643362 0.5392838733 0.9903183671 34.36609938
392 0.02391842092 0.4214793457 1.028030474 13.83689996
393 0.0002126953038 0.5798214056 0.9853547752 80.72829629
394 0.001850777103 0.4913023874 1.09807908 39.15214286
395 0.1522220472 0.507447215 0.9399735291 58.23629177
396 0.05461293969 0.4735446539 0.9624827914 49.32583221
397 0.005231159343 0.5277058417 1.001056949 25.89950635
398 0.0006512186024 0.4386739941 0.913726322 66.6661707
399 0.008201500557 0.5600251559 1.074370914 6.067960737
400 0.00596711438 0.4466658991 0.9778302945 61.01709196
401 0.0005369343924 0.555416126 1.03534972 36.2886591
402 0.003407152073 0.4657007949 0.9484036144 78.1963571
403 0.0517709126 0.5322675336 1.090102939 16.2855071
404 0.1253851317 0.4991401432 1.012122208 3.618950825
405 0.001345238205 0.5028916262 0.9508918718 69.19786417
406 0.0002018246046 0.4134935439 1.064012905 28.76339288
407 0.01559380296 0.5844243323 0.924461991 46.54527774
408 0.0252759514 0.4540252024 1.06188116 64.41693997
409 0.0001280189739 0.5441017237 0.9012366867 8.15053747
410 0.0008013149104 0.4332194213 1.013570365 52.54992912
411 0.2163158714 0.56860635 0.9749960886 22.8407867
412 0.08132804632 0.400377617 0.927485433 42.21021401
413 0.002094614297 0.5977967037 1.085590817 55.01154636
414 0.0003099807081 0.4873781404 0.997869564 11.75367473
415 0.009977066243 0.5144948408 1.04054543 82.97687852
416 0.01084255038 0.4108858438 1.094182749 45.26950823
417 0.000297271405 0.58806963 0.9423271982 27.50839686
418 0.002563908591 0.4767967191 1.030390247 70.41393129
419 0.06840406569 0.524295109 0.9814645479 4.855829421
420 0.2026187417 0.4567942187 0.9160845673 17.75065844
421 0.0008506631747 0.5421140512 1.07047916 79.68219833
422 0.0001035377121 0.4305235995 0.9585849332 34.92990205
423 0.02975374857 0.5705208279 1.003409091 59.67906786
424 0.01886994461 0.4901934136 0.9657457843 84.19262138
425 0.0001678118136 0.511057009 1.020726383 12.99022908
426 0.001467276975 0.4225135634 0.9080448035 53.7361011
427 0.1206874443 0.5761856597 1.053845455 40.95554224
428 0.04204424766 0.4423334753 1.043935572 21.48235389
429 0.004027499566 0.5589673936 0.9926659323 51.21222927
430 0.0004969587412 0.4699599288 1.079953836 9.615364568
431 0.00625912161 0.5287895558 0.9320047256 65.90245696
432 0.007504667424 0.4654043516 1.01589962 33.1941099
433 0.0006752456409 0.5366272971 0.9710753433 61.580217
434 0.004331400319 0.4469364144 1.057966518 21.16653867
435 0.06581063662 0.5509815825 0.9035720449 76.09964386
436 0.1641458094 0.4179045204 0.9939533949 73.99583727
437 0.00176098819 0.5841775747 1.042879261 1.439300701
438 0.0002624132642 0.4947550947 0.9298131604 43.36771059
439 0.02027389382 0.5032131638 1.081668544 29.2435405
440 0.0318472554 0.4352850378 0.9444935491 7.387524163
441 0.0001612918065 0.5628892099 1.092442874 67.96492011
442 0.001016568167 0.4519824861 0.9801519187 24.72784112
443 0.2744069746 0.5498905681 1.031421344 48.13339603
444 0.1066640837 0.4816145556 1.066336056 56.81558284
445 0.002746979274 0.5165124882 0.9205351425 37.7107035
446 0.0004022037525 0.4061183017 1.00821367 82.13080673
447 0.01294457509 0.5957073519 0.9532333339 15.21871798
448 0.01217113202 0.4288499618 1.002287964 68.75707508
449 0.0004285348554 0.5700934049 0.9596121244 7.173191519
450 0.002921988682 0.4588322077 1.072284549 48.91515729
451 0.1001132217 0.5422717275 0.9141791385 24.52390219
452 0.2919696235 0.4763207503 0.9866909325 37.92179366
453 0.0009543971071 0.5225752158 1.025265236 56.02018537
454 0.0001516221432 0.4109966984 0.9379803855 15.41941443
455 0.03392494833 0.5900600329 1.098624832 81.34580298
456 0.02160026951 0.4706544768 0.936156868 62.03059313
457 0.0002466860585 0.5305838326 1.075707755 31.99472809
458 0.001652702365 0.4420521067 0.9876355501 76.56041877
459 0.1745734233 0.5566592295 1.048865913 19.95675808
460 0.0617808209 0.4243569581 1.051845494 2.636737018
461 0.004607825567 0.5769316129 0.9101461424 73.54351563
462 0.0007192683367 0.4879360765 1.02204342 30.4513756
463 0.007053382306 0.5108257061 0.9645240212 42.90499019
464 0.006662678631 0.4958654208 1.086113085 12.1954904
465 0.0004668159506 0.5061541148 0.9254684715 84.40437001
466 0.003783901464 0.4164749518 1.03775027 40.17119727
467 0.0447686586 0.5814551583 0.9991761336 53.93745602
468 0.1134120645 0.4499280091 0.9016687846 50.99853515
469 0.001562688614 0.552141788 1.059774314 22.27514707
470 0.0001785823896 0.4627312364 0.972098838 65.69915655
471 0.01772052567 0.53524932 1.014774558 10.39776404
472 0.02794447495 0.4032491617 0.9520135954 27.05543734
473 0.000110205367 0.5949129788 1.009533256 46.4663057
474 0.000905601319 0.4840179687 0.9226329271 4.392471123
475 0.1903540708 0.5178671926 1.064332016 71.62112754
476 0.07283735699 0.4511410931 1.036354189 78.48215837
477 0.002409228219 0.5469736468 0.9751236118 18.20037547
478 0.0002791181151 0.4365913946 1.088192765 58.46862912
479 0.01153762057 0.5652465628 0.9486420926 35.39001785
480 0.00937039164 0.4600625008 0.991537986 9.018559013
481 0.0003299434179 0.538833583 1.046518349 64.2992211
482 0.002229886999 0.4275479643 0.9337909933 23.71916142
483 0.07640508665 0.5735086493 1.07959188 52.42185707
484 0.2303350486 0.407604997 1.01967907 55.13250772
485 0.0007529705768 0.5913382966 0.9684096709 41.34543496
486 0.0001202014901 0.479784156 1.055749454 83.10819306
487 0.02689632458 0.5213198522 0.9078001026 10.8785425
488 0.0165992534 0.4394432893 1.069926303 36.83435645
489 0.0001895834838 0.5618453518 0.9180708921 59.89227529
490 0.001263870197 0.4733380742 1.006185821 16.8208462
491 0.1335096017 0.5254236383 0.9572599815 77.08189867
492 0.04864989975 0.4930709872 0.9418767182 70.32462634
493 0.003628698015 0.5081672015 1.096271165 3.075198974
494 0.000571397529 0.4191472674 0.9843311617 47.66168166
495 0.005603654808 0.5795641895 1.029155465 28.22999928
496 0.008738078518 0.4146298368 0.9203097774 79.86285845
497 0.0006121900152 0.5874400781 1.068258866 13.95720285
498 0.004909480421 0.4977364877 0.9559221352 57.36050075
499 0.05808222716 0.500243951 1.007191796 39.28279893
500 0.1429007536 0.4686664706 1.092102829 25.78114896
501 0.001968888862 0.5333529919 0.9463021567 50.19321554
502 0.0002265623163 0.4439668231 1.034032564 5.939250165
503 0.02248014454 0.55396336 0.9790519865 67.54390721
504 0.03658184735 0.4844860854 1.041666438 44.24562981
505 0.0001442599872 0.5136287246 0.9968423009 31.81270511
506 0.001177433184 0.4027581688 1.083785355 72.06024686
507 0.2474770167 0.5990797186 0.9293907423 1.174201197
508 0.09160841576 0.4324008957 0.9697695844 18.72249248
509 0.003029929949 0.5657611242 1.018695305 75.34692665
510 0.0003548438249 0.4553544683 0.9055834275 33.25229911
511 0.01466692165 0.5465308137 1.057438957 63.30897564
512 0.01451008706 0.4324567093 0.9147966918 42.68584264
513 0.0003510494615 0.5663049795 1.07212104 29.88455304
514 0.00305072987 0.454811947 0.9598483957 73.30872433
515 0.09223728823 0.5464767179 1.001742797 2.085558227
516 0.2448306956 0.4850286093 1.099157127 20.47948653
517 0.001164842691 0.5136828238 0.9377312366 76.74584059
518 0.0001452503233 0.4027023526 1.025391454 32.51218116
519 0.03683297841 0.59853586 0.9860360935 62.22129033
520 0.02272312748 0.4680386923 1.048714611 81.44312652
521 0.0002290111716 0.5330179451 0.9882653104 15.86424579
522 0.001955464715 0.4443032062 1.075150382 56.13298549
523 0.1419264415 0.5545928538 0.9363809323 38.35114845
524 0.05871001815 0.414293451 0.9642626652 24.0453451
525 0.004962545173 0.586810581 1.022563508 48.77373965
526 0.0006080160947 0.4983642686 0.9095035104 6.699742624
527 0.008678502429 0.5005790012 1.051983918 68.61054924
528 0.005631104946 0.4936150843 0.9985493327 35.57026181
529 0.0005741966017 0.5082227793 1.037904907 58.99655569
530 0.003596920118 0.4190930251 0.9252416385 18.3962708
531 0.04822385253 0.5790218087 1.086667314 78.99443358
532 0.1341636297 0.4394975282 1.014257811 71.05948284
533 0.001270061598 0.56238773 0.9723631473 4.168125461
534 0.0001879232063 0.4727939805 1.05963274 45.90992879
535 0.01645388494 0.5253680632 0.9023086539 26.82582389
536 0.02676520896 0.4072701853 1.06449886 10.26154452
537 0.000119615522 0.5907102773 0.9220183332 65.21542161
538 0.0007596229756 0.4804135101 1.010075279 22.12344338
539 0.2323700362 0.521656381 0.9517745554 50.53028437
540 0.07603263218 0.4594331501 0.9488941949 54.37708926
541 0.002219016827 0.5384970568 1.087663811 40.27369867
542 0.0003328583861 0.4278827727 0.9757756881 84.83890266
543 0.009453177007 0.574136666 1.036224822 12.3030924
544 0.01143658121 0.4511951912 1.079071128 28.12230482
545 0.0002766737627 0.5475161688 0.9340516787 47.22722121
546 0.002421030096 0.4360475371 1.046379254 2.97276977
547 0.07319416122 0.5651907485 0.9921799533 69.88490064
548 0.1886870448 0.4037930166 0.9071696777 77.55007471
549 0.000897670488 0.5949687898 1.055900085 16.97264489
550 0.0001107452337 0.4839638732 0.968184936 60.37610523
551 0.02808136832 0.5173246739 1.020235778 36.97050124
552 0.01787708425 0.4492985101 0.9575084599 11.10806095
553 0.0001801601475 0.5518054012 1.005652861 83.6646447
554 0.001555070737 0.4630662885 0.9187250664 41.56985535
555 0.112859194 0.5358771021 1.069799415 55.69405742
556 0.04516417859 0.4955303714 1.029318304 51.90950966
557 0.003817331408 0.5055263361 0.9837129438 23.52335856
558 0.000464540347 0.4171044482 1.096815666 63.77138699
559 0.006630199648 0.5817915417 0.9416397763 8.838242856
560 0.007101802501 0.4248993337 1.007721611 63.4555762
561 0.0007242059622 0.5769858515 0.9556708882 33.72565301
562 0.004558553714 0.4878805039 1.068389089 75.4882493
563 0.06112019538 0.5102816127 0.9196585624 19.20112429
564 0.1757718592 0.4707100527 0.9796674417 0.7449388644
565 0.001664048017 0.5311279286 1.033866576 71.94737455
566 0.0002440481953 0.4415097278 0.946542052 31.36780155
567 0.02136929416 0.5566049883 1.091561668 44.14839873
568 0.03369364351 0.4759842237 0.9291272882 67.35328221
569 0.0001505883677 0.5219458625 1.084302964 5.421704636
570 0.0009647129752 0.4116247155 0.9962032929 50.00770126
571 0.29512545 0.5903948439 1.041808867 25.2584927
572 0.09943064829 0.4282219414 1.057285176 39.83407271
573 0.002902066606 0.5697585912 0.9062110897 57.59521733
574 0.0004331667426 0.4591687376 1.018141937 14.52395068
575 0.01230268527 0.5429010835 0.9699972726 80.08210099
576 0.0130844882 0.4816566359 1.024482575 6.621747455
577 0.0004065510358 0.517042611 0.9640334139 66.90356233
578 0.00272825041 0.4055864619 1.050970365 26.46892923
579 0.1059368464 0.5956639368 0.9122007756 49.54758768
580 0.2773729709 0.4358168809 0.9900792347 58.0481797
581 0.001027556028 0.5629326276 1.048379931 38.63727238
582 0.0001601921023 0.4519404024 0.9352741575 80.54545707
583 0.03163011656 0.5493604427 1.077754711 13.31675664
584 0.02005710163 0.4172630096 0.9406133 33.93934998
585 0.0002596072269 0.5838287946 1.097937413 62.66278017
586 0.001773077214 0.4951021586 0.9856189921 19.40442249
587 0.1652726604 0.5038533391 1.027513629 74.70585205
588 0.06510692007 0.4650572844 1.074925045 72.74211607
589 0.004285084303 0.5359871192 0.9134993967 0.5331873894
590 0.0006798810598 0.4475779286 1.001211493 44.93274148
591 0.007556185609 0.5513303652 0.9618558921 31.16644885
592 0.006228609871 0.4428638391 1.090241271 82.46720617
593 0.0004945361996 0.5590092389 0.9477608841 11.5603848
594 0.004063081646 0.4699163681 1.035869709 54.48622518
595 0.04241569816 0.5282578558 0.9775688462 42.03257291
596 0.1200991072 0.4902369717 0.9246859629 23.0729802
597 0.001460124216 0.5115887057 1.063455433 53.10889369
598 0.0001692944146 0.4219832022 0.9515215337 8.377470793
599 0.01903665816 0.5761438178 1.011970814 64.98116473
600 0.02989950514 0.4564456744 0.9743411513 47.01612884
601 0.0001040449157 0.5414722987 1.01369649 28.9177045
602 0.0008432134661 0.4311636344 0.9009874454 69.68420704
603 0.200844308 0.5708680382 1.062413356 3.757770676
604 0.06873915281 0.4102458116 1.040000165 16.1804877
605 0.002576468187 0.5877224231 0.998105743 77.76440958
606 0.0002946680768 0.4771452608 1.085427216 36.18874283
607 0.01074759802 0.5249368582 0.928102888 60.58004132
608 0.01006521145 0.4004210344 0.9816921437 66.33957727
609 0.0003127193107 0.5983285442 1.029836781 9.715190912
610 0.002084403547 0.4868480153 0.9429547621 51.64408686
611 0.08093159373 0.5144527597 1.094028875 21.58744295
612 0.218227001 0.4545553241 1.003551428 40.81680978
613 0.0008083944252 0.5441438021 0.9579458268 53.2496911
614 0.0001273948965 0.4331760073 1.070996669 12.83585033
615 0.02515273486 0.5680745121 0.9158210209 83.72185768
616 0.01545723976 0.4984999627 1.053304196 59.11491023
617 0.0002000571255 0.5025445586 0.9082846064 34.70288133
618 0.001351828209 0.4138423292 1.020560302 79.12314637
619 0.12599936 0.5850658469 0.9663611412 17.51853207
620 0.05131753338 0.4463171171 0.9313534122 5.033560451
621 0.003377314339 0.5547746141 1.080083966 70.9391828
622 0.0005395646425 0.4663409721 0.992414593 27.70161713
623 0.005996344966 0.5326145986 1.044465289 45.77927051
624 0.008145582848 0.4740763487 0.9033350106 14.73748584
625 0.0006467785844 0.5277493987 1.058510922 81.98687616
626 0.005287701004 0.4386321541 0.9704570271 37.23474168
627 0.05520323234 0.5594947958 1.016062366 56.66638195
628 0.1511841815 0.4215211883 1.081541564 48.22804451
629 0.001838158258 0.580351769 0.9304672364 25.17015955
630 0.0002149942741 0.49077069 1.042346203 68.07520729
631 0.02417694986 0.5074036546 0.9942017809 7.814203901
632 0.03917352275 0.4252345044 1.031977955 29.7635939
633 0.0001363251669 0.572733848 0.9799270915 43.55061948
634 0.001095078288 0.4624495843 1.092593413 1.954240836
635 0.2608517003 0.5396324169 0.9438630259 74.18385941
636 0.08668920862 0.478959859 0.9538752029 75.87782126
637 0.003249467385 0.5189580411 1.008074483 20.59720318
638 0.0003734366599 0.4083564334 0.9207957355 61.34291276
639 0.01362140161 0.5936753122 1.065815206 32.64025606
640 0.01332884938 0.4639776355 0.9502119729 56.09336042
641 0.0003890266476 0.5349168271 1.011637863 38.01593123
642 0.003119628205 0.4486560397 0.9235809175 81.25175407
643 0.0886027563 0.5523991434 1.062936278 15.34615071
644 0.2548734457 0.4161910016 1.034662429 7.245034105
645 0.001139115143 0.5827539133 0.9773380803 68.84995112
646 0.0001310710076 0.4961757043 1.089226203 24.43110467
647 0.04009726643 0.5049297344 0.9473318016 48.84323617
648 0.02324229736 0.4370901123 1.085104897 73.44954525
649 0.0002200371317 0.5641969075 0.9268040542 2.563394778
650 0.001795811554 0.4506656332 1.039467323 42.97841095
651 0.1572446047 0.5480946489 0.9969869152 30.54526745
652 0.05299099901 0.482925302 0.9007460471 31.90200911
653 0.005403759687 0.518314508 1.061195348 61.95859349
654 0.0006328101515 0.4043193337 0.9739257552 20.02884638
655 0.00848460267 0.5943935538 1.012695204 76.65304909
656 0.006143747472 0.4122942137 0.9348183256 22.36927989
657 0.000519276527 0.58977408 1.076712989 51.07171495
658 0.003509694635 0.4750953209 0.9898279183 10.32450571
659 0.05009242808 0.5228836874 1.047152004 65.60510226
660 0.1291587832 0.4585017174 1.050421501 84.49725143
661 0.001301624073 0.5435193663 0.911065926 12.26732761
662 0.0002077987896 0.4291091291 1.024125923 53.86553015
663 0.01508097411 0.5688224845 0.9627002478 40.07840451
664 0.02612288541 0.4883821521 1.000180404 18.12703862
665 0.0001242786207 0.5097310366 0.9614107879 78.3881826
666 0.0008285636166 0.423836484 1.073683432 35.48390496
667 0.2100968278 0.5779999729 0.9132342985 58.54205464
668 0.08409358823 0.4410044542 0.984473511 46.39430131
669 0.002034393955 0.5571591869 1.026954038 26.9627231
670 0.0003203674544 0.4717772909 0.939293821 71.71376324
671 0.009685567117 0.5301094217 1.097594544 4.464554046
672 0.0104853344 0.4452422258 1.043371285 41.43815331
673 0.000306014807 0.5537025714 0.9946408773 55.204508
674 0.002480632192 0.4674174013 1.082740548 10.80645356
675 0.07044987839 0.5336881552 0.9306897057 83.01556337
676 0.1960375929 0.4974296374 0.9715598794 64.39319085
677 0.0008761043736 0.5014648981 1.016579329 9.091901886
678 0.0001001266051 0.4149111167 0.9046484819 52.34843567
679 0.03062887959 0.5861439934 1.058847783 23.6252702
680 0.01832197966 0.455827258 0.9212211449 3.003355754
681 0.0001734454042 0.5454124819 1.066826505 70.23175093
682 0.001425353852 0.4319056112 0.9541083038 28.32279616
683 0.1247990129 0.5668073462 1.009284194 47.73360341
684 0.0408429655 0.4016853265 1.093124061 59.81909961
685 0.004164709164 0.599601814 0.9449796598 36.74021951
686 0.000482527439 0.4855821854 1.032304183 77.17594695
687 0.006469244104 0.513177976 0.981229835 16.89411054
688 0.007732950359 0.4810069151 1.071361808 50.26522057
689 0.0006536376595 0.521014051 0.9171626743 25.87386256
690 0.00445658496 0.406310915 1.004090469 67.45127214
691 0.06361089258 0.5916208163 0.9590708531 5.867166608
692 0.1688898598 0.4272861267 0.9432023589 14.03054034
693 0.001702126074 0.57478224 1.095253082 79.95683359
694 0.0002703956158 0.4603964243 0.9821503595 39.18891245
695 0.01962513086 0.5375825109 1.030880886 57.2870746
696 0.03294858109 0.4196711747 0.99374256 75.25404586
697 0.0001567611871 0.5784923963 1.044816646 18.65065464
698 0.00105017367 0.4926222414 0.9324890709 63.38090213
699 0.2663061957 0.5092645412 1.080633735 33.34509124
700 0.1101901861 0.4722186934 1.021798196 31.71857292
701 0.002665886308 0.525894616 0.9666225204 44.17244938
702 0.0004161124725 0.4404882716 1.05433767 1.247460158
703 0.01258096401 0.5613480646 0.9087320952 72.15430052
704 0.01180966323 0.4132153038 1.06085075 19.7748103
705 0.0004426742321 0.5857417913 0.9025500532 74.70769226
706 0.002839390872 0.4994439298 1.015259098 34.45889373
707 0.10356896 0.5016493287 0.9727785446 62.84490171
708 0.2837162466 0.466965135 0.9265404705 44.71556049
709 0.000987341067 0.5319415137 1.086989631 30.59117476
710 0.0001471191773 0.4453752495 0.9996681586 72.68705845
711 0.03504429896 0.5556677474 1.038437748 0.130415177
712 0.02087954815 0.4863033907 0.9760064529 25.9922171
713 0.0002538622103 0.5149486531 1.037432102 49.39784009
714 0.001599913319 0.4014290851 0.9493232762 5.995879397
715 0.1799167033 0.5972715685 1.088678878 66.57353341
716 0.05980749278 0.4337238729 1.010408231 80.82226858
717 0.004748861212 0.5675753748 0.9530841181 13.9102403
718 0.0006952688174 0.4535432694 1.065018017 58.16286784
719 0.007258565238 0.5452047847 0.9231233804 39.05825417
720 0.006889241313 0.4614830539 1.025951047 69.10499098
721 0.0004533949652 0.5405502161 0.9871815765 3.547105389
722 0.003910691486 0.4258343829 1.099499997 46.61719664
723 0.04346065508 0.5720850445 0.9390507175 28.85619261
724 0.117212216 0.409324679 0.9602934988 36.19452438
725 0.001517031307 0.5927557949 1.002773886 60.94391407
726 0.0001846550876 0.4783575024 0.9150617888 16.35876859
727 0.01721106314 0.5196093256 1.073362652 78.29040823
728 0.02878550623 0.4376442587 0.9106383581 55.08354886
729 0.0001066323822 0.5605316103 1.052532781 42.30293015
730 0.000932407883 0.474648764 0.9655958295 82.88424598
731 0.1840939574 0.5272257207 1.022920157 11.68158864
732 0.07499342441 0.491754197 1.076192104 8.22388256
733 0.002329997189 0.5063712256 0.9368367653 64.51090751
734 0.0002875185201 0.4209523985 1.049942539 22.74689263
735 0.0111635553 0.5808718245 0.988516628 52.47651057
736 0.009102662436 0.4944539784 0.9454254191 79.58822542
737 0.000341183981 0.5044527911 1.091031021 17.67731874
738 0.00216513272 0.4181793272 0.9783646993 59.75249116
739 0.07897005394 0.582863549 1.033540348 35.02379137
740 0.223646348 0.4482297342 1.067377788 27.41568548
741 0.0007782484398 0.5507272908 0.9192331512 45.19750098
742 0.0001167670827 0.4641365783 1.006511898 4.927910129
743 0.02781262689 0.5369567502 0.9554377854 70.50656921
744 0.01606010163 0.4050634004 1.017624973 51.28541192
745 0.0001952534554 0.5962359203 0.9688944193 21.57648386
746 0.001222231333 0.4826919755 1.056948314 65.80840045
747 0.1374364438 0.5160560057 0.9048976174 9.542108458
748 0.04704709078 0.4524609858 0.9957641983 13.06206913
749 0.003735426069 0.5487909403 1.040783788 84.28549996
750 0.0005528384095 0.4347832564 0.9289048208 40.86274726
751 0.005771247425 0.5639175149 1.083103981 53.66417745
752 0.009026942287 0.4302674958 0.9679235587 1.365956245
753 0.0005941176719 0.5718130987 1.018997886 73.9018691
754 0.00507925638 0.4571216691 0.9067221908 29.33743521
755 0.05645070821 0.5408450382 1.054866613 43.44112851
756 0.1478424797 0.4780373953 1.046027896 61.50821513
757 0.00191358354 0.5239958046 0.9908519851 33.10139314
758 0.0002340519601 0.4095730579 1.078521358 76.19227703
759 0.02181650798 0.5883464396 0.9329160189 21.23862412
760 0.03763911433 0.468858489 1.095591458 37.80483886
761 0.0001394380124 0.5292670066 0.9413921777 56.8887601
762 0.001213249571 0.4433597775 1.028274196 15.14545712
763 0.239557765 0.5584643725 0.9832547262 82.03675497
764 0.09439503052 0.4230431808 0.9173834141 68.05779393
765 0.002932971736 0.5751325704 1.069434277 7.459368967
766 0.0003650994099 0.4897381708 0.9563834347 48.06147776
767 0.01417667413 0.5121364316 1.005113821 24.63504076
768 0.01428077239 0.489281318 1.09077486 70.57815982
769 0.0003677806532 0.5117737891 0.9457551962 4.688044279
770 0.003003996092 0.4233524168 1.033088875 45.43411927
771 0.09668097861 0.5755421218 0.9788897889 27.3408777
772 0.2336642372 0.4430510214 0.9188789604 35.09440416
773 0.001183402648 0.5580545381 1.067609535 59.51163737
774 0.0001385573387 0.469315625 0.9548882822 17.91489458
775 0.03740142759 0.5296291692 1.006938958 79.51438533
776 0.02236668341 0.4100408899 0.9692238159 53.56892677
777 0.0002399541292 0.5887192745 1.017368432 41.12045695
778 0.001925753645 0.4777149152 0.9054223265 84.0258701
779 0.1487825915 0.5235722223 1.05649646 13.15536925
780 0.05603942954 0.4574446231 1.041015914 9.448463828
781 0.005042246237 0.5412683314 0.9954103872 66.06772632
782 0.0005800685685 0.4297999529 1.08353142 21.3152277
783 0.008813473333 0.57143979 0.9283556972 51.37707558
784 0.005718005903 0.4344698384 1.019449358 20.99940155
785 0.0005477388045 0.5635090997 0.9673984677 76.26452136
786 0.003654227524 0.4529197557 1.055122772 33.02723877
787 0.04602445416 0.549148608 0.9063924123 61.74547702
788 0.1406270428 0.4822336795 0.9914014898 43.20092812
789 0.001250606715 0.5156980488 1.045600838 29.4086916
790 0.0001968795552 0.4053771075 0.9332702111 73.82867228
791 0.01619386824 0.5966438616 1.078289613 1.604185808
792 0.02718149942 0.4644609755 0.94086747 24.89210718
793 0.0001141172862 0.5373753577 1.096043312 47.96557336
794 0.0007718235613 0.4477577202 0.982925331 7.552015674
795 0.2217998001 0.5503555922 1.028530739 67.79752049
796 0.07970566574 0.4186518211 1.069006837 82.29542744
797 0.002185299035 0.5832349645 0.9179325363 15.0511689
798 0.0003487639025 0.4941298643 1.004881694 56.9797805
799 0.009304882921 0.5040337037 0.9567372443 37.54292897
800 0.01091022031 0.420542839 0.9030991754 0.2250225795
801 0.0002809941237 0.5805626027 1.060423309 72.42869504
802 0.002310759512 0.4921168238 0.9731323542 30.85274521
803 0.07437430931 0.5068280881 1.01502697 44.62421078
804 0.1858086259 0.474286611 1.087441486 62.94048693
805 0.0009410933584 0.5267685691 0.9260157628 34.20151826
806 0.0001090012805 0.4380541073 1.03869429 74.96830515
807 0.0294250192 0.5608403582 0.9993387634 19.68249291
808 0.01705230184 0.4787810691 1.037005044 38.98730683
809 0.0001829515825 0.5199318154 0.9765559576 58.40338741
810 0.001484056391 0.4089518359 1.088447132 13.67168142
811 0.1146643277 0.592287977 0.9496774685 80.89512595
812 0.04446964108 0.4262077058 0.9525590271 66.50098003
813 0.00400147841 0.5725525793 1.010859703 6.23478279
814 0.0004571713353 0.4610597704 0.9227936018 49.16090752
815 0.006946616145 0.5402272465 1.065274176 26.06671092
816 0.007441606763 0.4531855861 0.9868277654 78.03140154
817 0.0007128023422 0.5447460245 1.026183173 16.45272227
818 0.004779058769 0.4341322798 0.9385015938 60.85191095
819 0.06018785769 0.5678888069 1.099927436 36.45545123
820 0.1786057299 0.401021158 1.002517345 28.59816374
821 0.001588256999 0.5969578533 0.9606228955 46.71213826
822 0.0002478588892 0.4866613572 1.072910799 3.454144723
823 0.02038580877 0.5154069334 0.915586498 69.36495015
824 0.03530166085 0.44574694 1.052764527 52.71767342
825 0.000148199458 0.5561397756 0.9102841673 22.67659901
826 0.001011251304 0.4665465118 1.023347216 64.58441828
827 0.2905866807 0.5316171262 0.9650463263 7.985967272
828 0.1010210826 0.4998630268 0.9371665424 11.92114544
829 0.002769536952 0.5019734271 1.075935944 82.81233619
830 0.0004398787813 0.4128439024 0.9890417175 42.37806723
831 0.01173507517 0.5852692893 1.049491066 54.84727001
832 0.01248886316 0.4400692796 0.994995074 23.88379558
833 0.0004130666463 0.5610240459 1.043139544 52.2543148
834 0.002602773962 0.4725900136 0.9312392149 9.182765065
835 0.1075816416 0.5263670145 1.082313495 64.13145844
836 0.2730311162 0.4922504473 1.016835483 83.27245231
837 0.001076694251 0.5087924318 0.9712300964 10.71070638
838 0.0001577622256 0.4200898776 1.05929925 55.29698736
839 0.03315901576 0.5788168889 0.9041233864 41.17802695
840 0.01914182545 0.4608044609 1.066594384 16.6540775
841 0.0002637363723 0.5378963133 0.921574962 77.24705625
842 0.001691319201 0.4269280745 1.008856761 36.66720017
843 0.1678174081 0.5743238486 0.9546574334 60.05717196
844 0.06407975432 0.4066684874 0.9446502572 47.49453805
845 0.004489429372 0.5920794908 1.093380596 28.39486301
846 0.0006694897025 0.4805985954 0.9807051199 70.15774365
847 0.007920482223 0.5207007283 1.032756031 3.240450285
848 0.006529674044 0.485208972 0.9166131636 57.19360714
849 0.0004870352253 0.5127105284 1.07178886 39.44808143
850 0.004257376608 0.4021085244 0.958716655 79.69574445
851 0.04175178933 0.5999246726 1.004322209 14.12205725
852 0.1219636865 0.4314819336 1.094801616 5.772062698
853 0.001392972345 0.5664847707 0.9437274558 67.7088148
854 0.0001720074353 0.4562001882 1.030624733 25.6143896
855 0.01817009682 0.5458804093 0.9824801439 50.35834352
856 0.03134103752 0.4152733747 1.045244081 72.22475642
857 0.0001024545748 0.5866012247 0.9931934319 1.006783526
858 0.0008834251788 0.4970197076 1.080865857 44.40987845
859 0.1976755028 0.5011560466 0.9321352553 31.64489986
860 0.069797623 0.4678268572 0.9671472341 33.41651482
861 0.00245766312 0.5339972958 1.021346347 63.14118305
862 0.0002993551276 0.4448796786 0.9090614963 18.88709576
863 0.01025713626 0.553245814 1.054081133 75.17939499
864 0.009910758777 0.4713048842 1.011186014 49.08261581
865 0.0003278163891 0.5297381157 0.9507366866 24.35935178
866 0.002051391541 0.4413284572 1.062679741 68.92492118
867 0.08479627913 0.5575781886 0.9239103187 7.00890203
868 0.2081514589 0.4235120011 0.9767889522 15.58716679
869 0.0008208924414 0.5775812544 1.035089863 81.18162748
870 0.0001215738799 0.4888542756 0.946977986 38.08928511
871 0.02555438261 0.5101028224 1.089458325 55.8556223
872 0.01522186149 0.4295675049 0.9273291511 76.39517711
873 0.0002097398553 0.5691805463 1.084653431 20.12361085
874 0.001330587332 0.4581879068 0.9973166997 61.86577959
875 0.1320326527 0.5431113439 1.03921117 32.16180125
876 0.04895441859 0.4754086576 1.0616224 30.28642779
877 0.003429957284 0.5232919989 0.9001965364 43.07221787
878 0.0005149718897 0.4118355488 1.012926944 2.471568827
879 0.006092812216 0.589416492 0.973571557 73.7103152
880 0.008275645503 0.4039964594 1.076969524 40.00599821
881 0.0006172260411 0.5939703656 0.9344889229 54.10426619
882 0.005369445937 0.4833927413 1.047603852 12.03055226
883 0.05265455528 0.5186877355 0.9893032031 84.57156776
884 0.1584034708 0.45019772 0.9114197431 65.5343324
885 0.001809048135 0.5477217104 1.05018938 10.56486807
886 0.0002253732613 0.4374126974 0.9632493773 50.83332342
887 0.02380596965 0.5646205695 1.02369849 22.44199018
888 0.03980376691 0.4964845477 0.9610810049 4.559971914
889 0.0001301114786 0.5053396784 1.000436559 71.45653486
890 0.00111214871 0.4157337546 0.912709203 27.22315852
891 0.2488395645 0.5823916649 1.074134899 46.30214113
892 0.09084029049 0.4491128068 1.026722297 58.63650482
893 0.003198406793 0.5527616749 0.9848277077 35.22571902
894 0.0003915112558 0.463668509 1.097167491 78.64960596
895 0.01341396454 0.5345073629 0.9398433302 18.03585626
896 0.01396532372 0.407937346 1.030093321 83.98247564
897 0.0003828657941 0.5933511982 0.9813627467 12.74350761
898 0.003270230219 0.4793312745 1.094480728 53.34525099
899 0.08724320355 0.5194305349 0.9424300525 40.55943938
900 0.2589430884 0.4620778857 0.9582996376 21.84904886
901 0.001087066757 0.5391604029 1.003319301 51.55272195
902 0.000133097287 0.4256531119 0.9163701441 9.809783115
903 0.03824601815 0.5730582451 1.07056923 66.08124932
904 0.02435524613 0.4911786312 0.9079548297 45.54231261
905 0.0002165795757 0.5077173617 1.053560357 27.77611601
906 0.001882730119 0.4211632315 0.965836052 70.86663448
907 0.1548499619 0.579893473 1.021011775 5.272438512
908 0.05384354355 0.4389898218 1.079852219 17.27995799
909 0.005157457059 0.5599535657 0.9317076033 79.1960392
910 0.0006426746221 0.4736679336 1.04403823 34.63196945
911 0.008093889121 0.5274359807 0.9929640966 59.35541461
912 0.005860090873 0.4659676634 1.058059067 7.721207771
913 0.0005273046717 0.5321470557 0.9038597187 68.33518166
914 0.003349327067 0.4467404103 1.015805824 24.91214588
915 0.05089232392 0.555097568 0.9707864227 48.32295068
916 0.1271768179 0.4134187469 0.9299181147 56.57437376
917 0.00136446226 0.5847433668 1.081969005 37.49569386
918 0.0002045077468 0.4988727976 0.9938479716 81.7278948
919 0.01580112846 0.5030123906 1.042578332 14.83143445
920 0.02491995475 0.43353817 0.9804521821 32.71540835
921 0.0001262157847 0.5685316481 1.031526483 61.10659846
922 0.0007907986492 0.4541454896 0.944192804 20.83672452
923 0.2134767878 0.543835046 1.092337253 75.80592666
924 0.08281303476 0.4872575667 1.00850154 74.25739552
925 0.002132858297 0.5147619957 0.9533256978 1.716320482
926 0.00031533362 0.4000583919 1.066046951 43.79177726
927 0.010149346 0.5978716914 0.9204415429 29.69332561
928 0.01064812261 0.4766727587 0.9634839088 13.55436794
929 0.0002919410315 0.5245654568 1.024909632 80.47160178
930 0.0025203855 0.41056991 0.911846583 38.70786998
931 0.06724295205 0.5881415201 1.05120211 57.80736137
932 0.2055131966 0.4308392469 1.047928459 49.78421103
933 0.0008628159282 0.570449415 0.9906043254 26.39409612
934 0.0001049146246 0.4569177026 1.077498552 66.97512761
935 0.03014946179 0.5418439891 0.9356039356 6.381886671
936 0.01860410837 0.4224414825 1.098364854 30.90517749
937 0.0001654475568 0.5765017843 0.9400641782 45.02444061
938 0.0014480258 0.4899232564 1.027745757 0.4395782249
939 0.1191038684 0.5111807786 0.9852651829 73.00142675
940 0.04281211229 0.4702298002 0.9140241047 74.44619686
941 0.004101050824 0.5286662627 1.074473191 19.49772767
942 0.000505538499 0.4424050789 0.9621852877 62.56753456
943 0.006367176403 0.5586515555 1.000954952 34.19703434
944 0.007611902367 0.4472549589 0.9481150752 64.90796285
945 0.0006848949572 0.5509070817 1.090009524 8.615725688
946 0.00438898537 0.4655248191 0.9781183498 52.86871864
947 0.06668563776 0.5363604421 1.035442651 23.14423153
948 0.161201744 0.4946343407 1.063711594 41.95838308
949 0.001729405308 0.5034804961 0.9243561862 54.72350226
950 0.0002579597079 0.4175854994 1.012422287 11.32117743
951 0.01992983401 0.5842523612 0.9509964446 82.53941504
952 0.03242876599 0.4522491504 1.013464364 60.67108704
953 0.000164236733 0.5497702913 0.9746949621 35.92682787
954 0.001034122684 0.4353597293 1.061985917 78.02307697
955 0.2791452847 0.5625704747 0.9015365686 16.08622481
956 0.1051618215 0.4060433244 0.9977763459 3.850432583
957 0.002708288139 0.5960265636 1.040256706 69.42389813
958 0.0003969251867 0.4813474141 0.9275781784 29.17473546
959 0.01277467669 0.5166330514 1.085879068 46.92023964
960 0.01200006395 0.4587119801 0.933697862 37.04387032
961 0.0004225121088 0.5425385363 1.079303249 60.13833164
962 0.002883726537 0.428531082 0.9916308241 17.2136255
963 0.09880237634 0.5701680472 1.046806687 77.47996333
964 0.2972914036 0.411315864 1.055643551 69.95989603
965 0.000971793979 0.5899849141 0.9074990807 2.736632628
966 0.0001542355771 0.4764414551 1.019783931 47.46659577
967 0.0345097289 0.5223081205 0.9687096516 28.05057726
968 0.02121352483 0.4419776551 1.005884602 8.746381439
969 0.0002422690028 0.5569779186 0.9571542628 64.03217215
970 0.001624704444 0.4703874772 1.070226468 23.2645341
971 0.1716158675 0.5307042509 0.9181755569 52.00328111
972 0.06266178162 0.4882033626 0.9840427265 55.60123846
973 0.004673526249 0.5107048105 1.029062149 41.82967282
974 0.0007288090323 0.4244318862 0.9421648715 83.40679806
975 0.007146934583 0.5766126381 1.096364199 11.20282035
976 0.006784146312 0.4167911256 0.9562200159 43.90998187
977 0.0004753269458 0.581383222 1.007294177 31.44051691
978 0.003849107959 0.4959890459 0.9200123776 71.87660976
979 0.04554018354 0.5058839085 1.068156967 0.9852758888
980 0.1118176049 0.4626078971 1.034318424 18.96433374
981 0.001540720277 0.5355190499 0.9791427277 75.5626011
982 0.0001762446053 0.4496123126 1.091818204 33.65328217
983 0.01748856645 0.5522134379 0.9462126505 63.69429705
984 0.02834283968 0.4842883658 1.083875912 80.34352941
985 0.0001117763035 0.5177433768 0.9296767993 14.43274298
986 0.0009176171215 0.4033209072 1.041577129 57.68964218
987 0.1928795613 0.5945969958 0.9965574915 39.57589184
988 0.07153350468 0.4365199355 0.9056859931 25.51896358
989 0.002366098636 0.5655620687 1.057736642 49.91552589
990 0.0002743886136 0.4508711725 0.9696674885 5.517107304
991 0.01134211134 0.5470971769 1.01839809 67.09608929
992 0.009541188506 0.4274733085 1.072572506 62.31379502
993 0.0003359577086 0.5738275396 0.9142715951 32.25204973
994 0.00226832216 0.4597956816 1.001998951 77.00272446
995 0.07772210843 0.538953824 0.9595186116 20.38376468
996 0.2270977176 0.4800512617 0.9382807476 2.176436605
997 0.0007423883871 0.521199134 1.098730075 73.04695646
998 0.0001186274625 0.4076801293 0.9863902921 30.14304296
999 0.02654414459 0.5910191206 1.025159715 42.59173697
1000 0.01683594365 0.4732176425 0.9877405964 68.53653689
1001 0.0001922865911 0.5256906483 1.04916646 6.936862487
1002 0.001280635192 0.4391245898 0.9360515308 48.53469962
1003 0.1352804498 0.5619198168 1.075406918 24.11740689
1004 0.04777883595 0.4194662526 1.022136073 38.27809365
1005 0.003563723666 0.5794892481 0.964811793 56.37107303
1006 0.0005617177267 0.4931918962 1.051751796 15.62422795
1007 0.005508720501 0.507899905 0.9098573256 81.51420036
1008 0.008615233003 0.4980066806 1.037648752 26.56633574
1009 0.0006035840403 0.5001203364 0.9988791153 46.0030872
1010 0.004845209717 0.4147017626 1.086215847 4.073057016
1011 0.05732191835 0.5871239178 0.9257667337 71.3170103
1012 0.1455060029 0.4438951837 0.9720089503 78.73331911
1013 0.002004785911 0.5542790432 1.014489552 18.48779276
1014 0.0002304665486 0.4683967542 0.9017591443 58.90309329
1015 0.02286755553 0.5334763208 1.060059793 35.82940545
1016 0.03592699604 0.4030741384 0.9223477362 12.53956899
1017 0.0001416774532 0.5990079835 1.064242326 84.76423658
1018 0.00115748237 0.4846098907 0.952299271 40.34510705
1019 0.2432834565 0.513358341 1.009623432 54.13740564
1020 0.0929143137 0.4552309487 1.087895932 50.76771851
1021 0.003073119374 0.5468007209 0.9485403782 22.04974499
1022 0.0003595521328 0.4320854032 1.036652255 65.28585217
1023 0.01486151788 0.5658325728 0.9752265589 10.02087295
1024 0.01482491427 0.4026182355 1.070399033 30.38465094
1025 0.0003586388363 0.5984750185 0.9161997059 42.84882437
1026 0.003092588293 0.4851390477 1.003490661 2.578787357
1027 0.09349857451 0.5138180519 0.9584712384 73.47533233
1028 0.2443466268 0.4547018901 0.942208864 76.57508068
1029 0.001162486304 0.5463411083 1.094259775 19.98197883
1030 0.0001416050267 0.4325412078 0.9815812474 62.05727253
1031 0.03590585395 0.5663654394 1.030311587 32.01117385
1032 0.02276945876 0.4982557375 0.992742959 15.3619513
1033 0.000229460596 0.5004449176 1.043817239 81.27778164
1034 0.002005932865 0.4143794755 0.9319260642 37.85490703
1035 0.1455827173 0.5868725669 1.080070534 55.96353303
1036 0.05746693239 0.4442175632 1.020841522 48.94167472
1037 0.004857249325 0.5545304865 0.9656656589 24.53986141
1038 0.0005998211932 0.4681476049 1.05373176 68.77222352
1039 0.008560878637 0.5331516473 0.9081263728 7.198574236
1040 0.005489449304 0.4726602783 1.042799136 58.49547064
1041 0.0005597777756 0.5252591506 0.9940685343 35.40630148
1042 0.003589588152 0.4395598955 1.081750114 78.4969824
1043 0.04812922988 0.5624733729 0.9296994649 18.2254341
1044 0.1359961877 0.4190310393 0.9709570099 4.334683586
1045 0.001287507814 0.5789357843 1.015976647 71.55278211
1046 0.0001919888236 0.493749168 0.9036887437 26.9888748
1047 0.01681062625 0.5083313104 1.057887857 46.40997776
1048 0.02640284449 0.4278223127 0.9206121685 65.71414287
1049 0.0001180015019 0.5740521675 1.066217722 10.42330888
1050 0.0007434940322 0.4595687596 0.9531546732 51.02489045
1051 0.2274535197 0.5386071138 1.00833037 22.29126842
1052 0.07799015748 0.4802782821 1.092558012 40.10414852
1053 0.002276321153 0.5215459425 0.944413423 53.88096579
1054 0.0003335167787 0.4073310267 1.031307649 12.13786515
1055 0.009472309156 0.5907943944 0.9802334888 84.33651079
1056 0.01141483232 0.4838538222 0.9358239228 47.72822393
1057 0.0002761602691 0.5171890585 1.077718393 28.28634748
1058 0.002360380244 0.4038775092 0.9903847141 70.38243414
1059 0.07136600316 0.5950292557 1.047708994 3.143524136
1060 0.192789884 0.435963426 1.051371987 16.8060019
1061 0.000917259644 0.5651299011 0.9120166006 77.05686031
1062 0.0001122732946 0.4513056237 1.024737853 36.80753519
1063 0.02847013756 0.5476514028 0.9633119902 59.8759714
1064 0.01749564098 0.4170188112 1.001124785 83.16583858
1065 0.0001763241463 0.5817291684 0.9623553623 10.94638145
1066 0.001533805671 0.495639278 1.074301468 55.19953621
1067 0.1113243841 0.5056600442 0.9138521403 41.40194545
1068 0.0452472731 0.4629577633 0.9854852092 23.69282638
1069 0.003824646505 0.5357430125 1.027965548 52.40571546
1070 0.0004764496232 0.4493845286 0.9398445152 9.003552431
1071 0.006800487858 0.551867393 1.098145426 64.27369653
1072 0.007200230815 0.441447736 0.9508269455 33.22563998
1073 0.0007341871569 0.5565189699 1.012252642 63.29250962
1074 0.00465796142 0.4708441423 0.9245283373 18.7078103
1075 0.06245017056 0.5312364537 1.063883891 75.32172617
1076 0.1713789775 0.4877467958 1.035222291 72.11821679
1077 0.001622385906 0.5101727061 0.9778981302 1.242364235
1078 0.0002435990313 0.424961707 1.090228757 44.31233421
1079 0.02132833567 0.5770714885 0.9483341679 31.86889119
1080 0.03455955771 0.4590335036 1.085658652 5.924081458
1081 0.0001544466331 0.5427906509 0.9273580031 67.51854476
1082 0.0009665466498 0.4282827888 1.040475984 25.75465179
1083 0.295672876 0.5698427023 0.9979953831 50.17723606
1084 0.09807698337 0.4115642495 0.9013671199 57.42736711
1085 0.002862426221 0.5903103514 1.061816233 39.33947154
1086 0.0004239500537 0.4761198392 0.9748670755 79.92034185
1087 0.01203999619 0.5220559135 1.013636713 14.02520393
1088 0.0128072021 0.4518299639 0.9685386386 66.73417193
1089 0.000397905029 0.5492252147 1.019612772 6.125443974
1090 0.002691365673 0.4359009979 0.9076697178 49.38250498
1091 0.1044998411 0.5629934691 1.055814334 25.96637255
1092 0.2779438339 0.4055019634 1.046587842 39.13616353
1093 0.001029623631 0.5956034768 0.9914121184 58.20979445
1094 0.0001643333604 0.4817666929 1.079523996 13.81153767
1095 0.0324453368 0.5171782205 0.9339184687 80.71312743
1096 0.02001721572 0.4474919042 1.096145296 62.82916398
1097 0.0002590711892 0.5512683794 0.9419462102 34.4328033
1098 0.001728493179 0.4651658155 1.029282941 74.86873371
1099 0.1611094951 0.5361212028 0.9842632776 19.90462044
1100 0.0665203131 0.494993246 0.9180045942 0.03195842262
1101 0.004377907963 0.503719637 1.07005527 72.57831993
1102 0.000689243792 0.4173486525 0.9573248623 30.66883856
1103 0.007659657627 0.5838911619 1.006055437 44.76208417
1104 0.006389239273 0.4219208349 0.9464311237 11.72815031
1105 0.0005073129945 0.5760581749 1.092036531 82.96187178
1106 0.004071195998 0.4903706739 0.9789216025 42.19407256
1107 0.04250365338 0.5116976183 1.034097445 54.98521116
1108 0.1184681573 0.4697822845 1.068328358 52.60643977
1109 0.001440405636 0.5281493247 0.9201839091 22.90781502
1110 0.0001656966476 0.442925825 1.007123912 64.48477908
1111 0.01863295376 0.5590952633 0.9560496112 8.208182831
1112 0.0303094096 0.4770096513 1.018569437 28.74708946
1113 0.0001054761465 0.5248268012 0.9698390771 46.518456
1114 0.0008614658274 0.4103062715 1.057566433 3.59391294
1115 0.2052074813 0.5878069216 0.9055155426 69.1830194
1116 0.06700662831 0.4311027929 0.9967760038 78.26468274
1117 0.002511721837 0.5707839211 1.041795405 16.34331442
1118 0.0002940640658 0.4565809024 0.9294556223 61.07344064
1119 0.0107260588 0.5415827371 1.083654971 36.35520089
1120 0.01008422992 0.4330915147 1.025378981 9.547505197
1121 0.0003133245604 0.5680140462 0.986609317 65.84483187
1122 0.0021378653 0.4546653751 1.098509646 21.42586351
1123 0.08301370197 0.5442794176 0.9380605601 51.14518068
1124 0.2135600866 0.4867375828 0.9596907366 53.75222229
1125 0.0007911668714 0.5143175257 1.002171311 40.9818977
1126 0.000125651379 0.4005051455 0.914102158 84.21816607
1127 0.02480963178 0.5983893916 1.072402833 13.00521555
1128 0.015794008 0.4662320655 0.910029489 34.87357363
1129 0.0002044251498 0.5324808905 1.051924105 59.6125058
1130 0.001370506832 0.4464027541 0.9646423062 17.68231254
1131 0.1277500875 0.5548369873 1.02196644 79.62441127
1132 0.05121779367 0.4137563108 1.075626139 70.43898944
1133 0.003371007491 0.5850038551 0.9362706119 4.87065393
1134 0.0005260378116 0.4986084878 1.048946088 45.28579138
1135 0.005846285296 0.5026786482 0.9875203652 27.53523886
1136 0.008034595304 0.4906366004 1.059888058 82.15618929
1137 0.000637917229 0.5072951294 0.9015871683 15.23386658
1138 0.005174935461 0.4215831801 1.014659373 56.8315419
1139 0.05402349044 0.5804377874 0.9721790133 37.73722109
1140 0.1550713306 0.4385697808 0.9255470829 24.67118862
1141 0.001885333438 0.5594091589 1.085996431 48.06650956
1142 0.0002154136209 0.4742100568 0.9990991538 7.319502668
1143 0.02422225715 0.5278583053 1.037868555 67.90745714
1144 0.03819377205 0.408295586 0.9750069592 43.38415587
1145 0.0001329054475 0.5935912011 1.036432802 29.27022038
1146 0.001093016892 0.479095093 0.9487603769 74.02105754
1147 0.2603487521 0.5190684736 1.088115785 1.453963085
1148 0.08789236884 0.4623139689 1.009451641 21.09835489
1149 0.00329441579 0.5395223659 0.9521273401 76.04169467
1150 0.0003815961513 0.4252949703 1.064412191 33.13794361
1151 0.01391796307 0.5728183405 0.9225177415 61.51349281
1152 0.01340690889 0.4962605784 1.006767977 38.51173963
1153 0.0003912870237 0.5049898189 0.9547170665 56.2625974
1154 0.003212431638 0.4160798062 1.067780115 15.84887854
1155 0.09123156706 0.5826194422 0.9190497763 81.41731411
1156 0.2504197251 0.4487668537 0.9786709044 68.68850246
1157 0.001119124464 0.5525339959 1.032870232 6.746625379
1158 0.0001297890967 0.46389238 0.9459760055 48.6750758
1159 0.03970328681 0.5348571241 1.090995428 23.93616516
1160 0.02365718656 0.4044286218 0.928136857 2.069782978
1161 0.000223954672 0.5945268804 1.08331272 73.28267143
1162 0.00181365326 0.4828385206 0.995631141 30.04555191
1163 0.1587947301 0.5182532791 1.041236528 42.81569537
1164 0.05268550906 0.4507520331 1.056325441 62.12286699
1165 0.005372197366 0.5481562592 0.9052511612 32.40340922
1166 0.0006145685994 0.4369804427 1.017539064 76.82355299
1167 0.008239645421 0.5640639624 0.9693945942 20.5259616
1168 0.00608328713 0.4292420743 1.078508119 50.57688357
1169 0.0005142055876 0.568932154 0.9334884817 22.20103165
1170 0.003448155412 0.4584401071 1.045379656 65.10660661
1171 0.04921636095 0.5434329664 0.9911805434 10.16316423
1172 0.1329928753 0.4751565497 0.906563765 12.43298819
1173 0.001340324304 0.5229704687 1.055294366 84.99985846
1174 0.0002090030289 0.412160887 0.9672282657 40.24752164
1175 0.01516953008 0.5896647919 1.019278914 54.36143814
1176 0.02536831552 0.4718369938 0.956908654 78.88537777
1177 0.0001206980044 0.5301946772 1.005053243 18.29748283
1178 0.0008237365185 0.4408696016 0.9177622885 59.04339538
1179 0.2088823924 0.5570483729 1.068836449 35.64825809
1180 0.0849239043 0.4239709551 1.028749194 26.80005454
1181 0.002054575134 0.5781111684 0.9831436407 45.89451848
1182 0.0003260662182 0.4883220676 1.095822168 4.29761325
1183 0.0098586086 0.5096461626 0.9406464718 71.22019815
1184 0.01030259016 0.4150219366 0.999557991 55.69942171
1185 0.0003007043746 0.58627884 1.038913378 41.60631923
1186 0.002456556796 0.497344376 0.9257953964 83.51397669
1187 0.06976933309 0.5014052011 1.08722126 10.96787737
1188 0.1972006776 0.4675022813 1.015199128 8.926326167
1189 0.0008813426874 0.5337482337 0.973304658 63.89049897
1190 0.0001031099462 0.4451310243 1.060253815 23.45606821
1191 0.03154389516 0.5535681063 0.9029295355 51.85261255
1192 0.01821272605 0.4856685912 1.065446283 69.73464063
1193 0.0001724243149 0.5132395804 0.922965944 2.832826683
1194 0.001384034666 0.401575651 1.010690249 47.2321778
1195 0.1211868027 0.5994688747 0.9523893377 28.15852788
1196 0.04156506583 0.4320149053 0.9498967523 36.9029704
1197 0.004238534871 0.5669406669 1.088666175 60.31880011
1198 0.0004872245693 0.4557404706 0.9763355477 17.06096901
1199 0.006532717595 0.545351259 1.036784875 77.66959437
1200 0.007963846928 0.4604576472 0.9154147247 25.37796929
1201 0.0006731236832 0.5376692982 1.072738885 50.09606845
1202 0.004483298712 0.427152806 0.9607927797 5.364523642
1203 0.0639873015 0.574672946 1.002687369 67.28562723
1204 0.1672609792 0.4064438542 1.099707818 80.11819992
1205 0.001685581011 0.5917304918 0.9382821219 14.5290314
1206 0.0002656991806 0.4809453107 1.026403155 57.4553173
1207 0.01928338304 0.5209276451 0.9870476013 39.68376964
1208 0.03327134262 0.4406227367 1.04927141 19.14418411
1209 0.0001582895476 0.561459266 0.9888222966 75.42100201
1210 0.001068806147 0.4721586149 1.076155975 33.84488911
1211 0.2710103938 0.525809736 0.9373863384 63.54353539
1212 0.1070024255 0.4926819384 0.964874598 44.00809102
1213 0.002588565525 0.5093498027 1.023175247 31.21725767
1214 0.0004136565614 0.4195363281 0.9104539938 71.98388149
1215 0.01250613793 0.5783815764 1.052934595 0.750260083
1216 0.0117418057 0.445486445 0.903953127 74.54519833
1217 0.0004401104863 0.5558022184 1.05912885 19.27487311
1218 0.002757657566 0.466880261 0.9714014946 62.67813048
1219 0.1005799964 0.5318814293 1.017007021 33.96517933
1220 0.288775251 0.4995291853 1.082092363 31.08851417
1221 0.00100486978 0.5017090317 0.931018229 44.8858402
1222 0.0001485745885 0.4131044898 1.043358012 0.6319153542
1223 0.0353893632 0.5856069388 0.9952133959 72.85123189
1224 0.02051492819 0.4536300508 1.03253486 49.5633406
1225 0.0002494175865 0.5452660136 0.980484185 26.49500446
1226 0.001584344399 0.4336145848 1.093599114 66.74250567
1227 0.1781523095 0.5674420482 0.9448685393 6.491952515
1228 0.06015706053 0.4015387546 0.9544872191 13.41523873
1229 0.004776253257 0.5974045137 1.008686305 80.65417027
1230 0.0007159163267 0.4862169908 0.9217463024 38.55958326
1231 0.007473781275 0.5148870427 1.066765966 58.00168136
1232 0.006956971757 0.4784191128 0.9827008855 3.711234336
1233 0.0004578873833 0.5196957255 1.030845335 69.60655591
1234 0.003980179594 0.4091917338 0.9435086034 29.02653676
1235 0.04423492515 0.5926461253 1.094582904 47.11449186
1236 0.1138312784 0.4259677095 1.004492852 60.45012732
1237 0.001473340644 0.5721943326 0.9588874448 36.02780524
1238 0.0001835828112 0.461421825 1.071617852 77.7905228
1239 0.01711242678 0.5404634347 0.9164420098 16.19620263
1240 0.02963853513 0.421087251 1.054251726 42.14165073
1241 0.0001098007116 0.5809826385 0.9092323245 54.58499114
1242 0.000937800677 0.491694494 1.021175379 11.51360258
1243 0.1851671814 0.5062859701 0.9669760307 82.38915242
1244 0.07425910072 0.4747088484 0.932356053 65.00687502
1245 0.002307287962 0.5273105947 1.081086413 8.392940159
1246 0.0002824803947 0.4375097876 0.9929745359 52.97938231
1247 0.01096877604 0.5604204148 1.045025426 22.91228849
1248 0.009263136751 0.4642218398 1.089678369 17.51311
1249 0.0003472253602 0.5370164473 0.9471977944 79.08674028
1250 0.002186184082 0.4481189143 1.034870219 34.85352702
1251 0.07974152355 0.5505924443 0.9765695436 59.25511614
1252 0.2223237764 0.4182905287 0.9240801336 45.69121047
1253 0.0007736816102 0.5829980141 1.062849797 27.58248188
1254 0.0001133834562 0.4943690984 0.9505649468 71.00653189
1255 0.02700874547 0.5043927126 1.011014033 5.09039883
1256 0.01615470773 0.434892932 0.9737414289 21.73768602
1257 0.0001964186394 0.5640504541 1.013096956 51.78404689
1258 0.001258624494 0.4523745799 0.9000247508 9.710171777
1259 0.1415352375 0.5487293359 1.061450474 66.30341675
1260 0.04622907065 0.4827787628 1.039431163 83.78945264
1261 0.003670645228 0.5161172286 0.9975365471 12.89309133
1262 0.0005474833552 0.4049541064 1.084433825 53.1613855
1263 0.005715781059 0.5961025996 0.9271096908 40.6972716
1264 0.008765896376 0.4097063785 1.023529048 74.06444029
1265 0.0005769102569 0.5884557337 0.9630796995 1.865816177
1266 0.005049529177 0.4779761724 1.050361498 43.60782248
1267 0.05611603355 0.5239090173 0.9115920968 29.83122686
1268 0.1492890179 0.4571832735 0.9890827809 32.60413353
1269 0.001932159148 0.5409314441 1.047383671 61.33785563
1270 0.0002381927612 0.4301345566 0.9347081944 20.73704415
1271 0.02220146387 0.5717034232 1.077188554 76.02818339
1272 0.03727681157 0.4897982493 0.9396229522 56.72333939
1273 0.0001380894915 0.5122213116 1.096947253 37.30197171
1274 0.001192226968 0.4229087157 0.9850469237 81.86770292
1275 0.2353888604 0.575021369 1.026941373 14.6494638
1276 0.09721169949 0.4434946241 1.073965418 7.954447805
1277 0.003020258501 0.5585751925 0.9125395754 68.22581498
1278 0.0003672724613 0.468798792 1.000608729 25.13363441
1279 0.01426039979 0.5291817451 0.961253321 48.2227415
1280 0.01414260764 0.4692051925 0.9475519851 5.18435251
1281 0.0003642391115 0.5294939352 1.089446622 70.7475252
1282 0.002951730268 0.4431351325 0.9771190468 27.84340873
1283 0.09500610137 0.5581153855 1.03444316 45.59920735
1284 0.2406191215 0.4232679242 1.063105958 59.35005777
1285 0.001218719067 0.5754816558 0.9237503566 34.59549814
1286 0.000139375111 0.489391369 1.011465506 79.34669945
1287 0.0376238946 0.5119094046 0.9500398573 17.42014933
1288 0.02171896032 0.4297139345 1.012864829 40.62697798
1289 0.0002330159013 0.5713777982 0.97409524 53.40254835
1290 0.001914329308 0.4575531483 1.061023035 12.65517604
1291 0.1479112495 0.541402421 0.9005738745 83.86296342
1292 0.05658320238 0.4776060086 0.9972071504 66.23150696
1293 0.005091561677 0.5234385142 1.039687704 9.949728576
1294 0.0005903062191 0.4101265268 0.9265849816 51.54776805
1295 0.008969433941 0.5887816478 1.084885678 21.81282311
1296 0.005752106322 0.4053147342 0.9625301948 75.76981997
1297 0.0005509633037 0.5965582246 1.023956106 20.83165155
1298 0.003763222682 0.4823673876 0.9112379046 61.24650592
1299 0.04739505855 0.5158069555 1.050593244 32.86570398
1300 0.1381887776 0.4527856661 1.046932199 29.5738514
1301 0.001228866761 0.5490400828 0.9896078719 43.7034077
1302 0.0001949866357 0.4345318303 1.076932395 1.773498785
1303 0.01603694578 0.5635951182 0.935037973 74.32505318
1304 0.027662911 0.4939942488 1.097374693 48.46326108
1305 0.000116129545 0.5039236527 0.9390738301 25.06268707
1306 0.0007793606277 0.418712287 1.027173501 68.29867235
1307 0.223955485 0.5833194571 0.9846931141 7.715888927
1308 0.07923764227 0.4476968728 0.9130642831 14.88836719
1309 0.002172367627 0.5502714811 1.073513563 81.79514953
1310 0.0003386847137 0.4645962095 0.9615827162 37.37646552
1311 0.009035284372 0.5374857903 1.000352186 56.48640682
1312 0.01123443447 0.4379696088 1.058676995 72.92347623
1313 0.0002893222047 0.5607798982 0.9044778347 0.3926927783
1314 0.002324221852 0.474396668 1.016750479 45.12310208
1315 0.07480418341 0.5269041786 0.9717308898 31.0143598
1316 0.1839969497 0.4920063853 0.9304691069 34.03643572
1317 0.0009318747502 0.5066928601 1.082519803 62.43793009
1318 0.0001070998573 0.420626956 0.9948595863 19.51310267
1319 0.02890952169 0.5806234442 1.04359014 74.47200151
1320 0.01722119736 0.4609508578 0.981009276 57.90577696
1321 0.0001847495329 0.5400935443 1.032083389 38.81664968
1322 0.001510501232 0.4262933487 0.9451983178 80.39389682
1323 0.116702217 0.5726149466 1.093342955 13.50788543
1324 0.04318907492 0.4088658115 1.009113363 6.397664296
1325 0.003886072322 0.5922259912 0.9539377144 67.00117814
1326 0.0004545495642 0.4788896002 1.066997712 26.23309457
1327 0.006906251266 0.520065899 0.9213921102 49.654361
1328 0.007311347009 0.4865272736 1.031101876 15.95633678
1329 0.0007003573243 0.5152984023 0.9823714888 77.86211342
1330 0.004732173712 0.4010831438 1.095034757 35.95299746
1331 0.05960193682 0.5970438777 0.9429838942 60.68674561
1332 0.1796352624 0.4340699125 0.9592412559 46.87363807
1333 0.001597534099 0.567803164 1.004260726 29.09714956
1334 0.0002552088689 0.4533192882 0.9169911334 69.53271582
1335 0.02099128922 0.5448549371 1.071190413 3.948810175
1336 0.03509707692 0.412783061 0.9089025475 23.16999818
1337 0.0001473473537 0.5851851722 1.054507887 52.88413164
1338 0.0009820707133 0.4999982549 0.9664509412 8.486240273
1339 0.2822230691 0.5020838656 1.021626852 64.74724517
1340 0.1028149497 0.4664109023 1.080854666 82.64847829
1341 0.002818931872 0.5315070692 0.9327102438 11.41995796
1342 0.0004442083522 0.4458074 1.044598367 54.67665481
1343 0.01185112209 0.5562242741 0.9935240392 41.88039456
1344 0.01261067304 0.4200057665 1.038657223 52.09134859
1345 0.0004171145987 0.5787560415 0.999887774 23.3836619
1346 0.002648740827 0.4923608799 1.086769793 63.9648153
1347 0.1094899691 0.5089276658 0.9263204919 8.689550818
1348 0.2651111653 0.4724799626 0.9729504613 11.20823973
1349 0.001045541916 0.526231399 1.015430869 83.44320683
1350 0.0001568245258 0.4401537722 0.9023800263 41.67902951
1351 0.03296343539 0.5610845119 1.060680869 55.46103018
1352 0.0197123995 0.4804900702 0.9232953466 77.41236599
1353 0.0002716101893 0.5205666387 1.065189748 17.15638688
1354 0.001701333876 0.4067545058 0.9529140528 60.22663993
1355 0.1688239846 0.5921414826 1.010238401 37.16340581
1356 0.06345712736 0.4268424375 1.088898295 27.90034195
1357 0.004446147383 0.5742614754 0.9495429352 47.32662799
1358 0.000657828831 0.4609133676 1.037212308 2.741644322
1359 0.007782883711 0.5380300215 0.9757864181 69.99606399
1360 0.00649125793 0.4560664801 1.073190351 39.61201674
1361 0.0004841328993 0.5457715027 0.9148896277 57.69469694
1362 0.004134134436 0.4315443069 1.002943522 14.29289932
1363 0.04054130295 0.5665704077 0.9604629952 80.19316998
1364 0.1241252035 0.4020465326 0.9388316326 67.21550065
1365 0.001417594551 0.5998386541 1.099280766 5.605539721
1366 0.0001736957602 0.4853430616 0.9874017995 49.85833033
1367 0.0183470427 0.5128190536 1.026171416 25.45132317
1368 0.03079704325 0.4448192127 0.988297583 0.8450245438
1369 0.0001006685536 0.5531613214 1.049723258 71.72600951
1370 0.0008748946252 0.4679624727 0.9370569373 31.47704981
1371 0.1957577437 0.5341073468 1.076412512 43.91527712
1372 0.07021521684 0.4968844736 1.022747812 63.6373423
1373 0.00247225383 0.5010456141 0.9654237261 33.58604945
1374 0.0003082969725 0.4153342221 1.052702473 75.68177197
1375 0.01056271421 0.5866853358 0.9108078094 19.05235816
1376 0.009625181027 0.4887442186 0.9552661946 24.19533413
1377 0.0003183460722 0.5099672129 1.006340543 48.58160834
1378 0.002039541575 0.4235964997 0.9194035919 6.83814228
1379 0.08430258821 0.5776417144 1.067547994 68.42741332
1380 0.2102171262 0.4412443401 1.033322081 81.67485677
1381 0.0008290008515 0.5575173471 0.9781461908 15.75377463
1382 0.0001237454338 0.4714153226 1.091251964 56.35572035
1383 0.02600885044 0.5298733437 0.9456466043 38.25226667
1384 0.0150732718 0.4117499059 1.082885668 20.28528497
1385 0.0002076766046 0.5893541247 0.9286863677 76.89400889
1386 0.001307311662 0.4755175702 1.041004789 32.32973617
1387 0.12971709 0.5234257011 0.9959853392 62.36029606
1388 0.05040975109 0.4580793757 0.9047260642 42.57597629
1389 0.003531762499 0.5429772602 1.056776907 30.11697549
1390 0.000517997807 0.4296535293 0.9690648098 73.20802055
1391 0.006128144695 0.5692425322 1.017795217 2.306224103
1392 0.008422953034 0.4373507116 0.9331346646 54.26731727
1393 0.000628241495 0.5645345451 1.078740239 40.50604702
1394 0.005422398833 0.4503318036 0.9906314138 84.73812605
1395 0.05317789143 0.5478302415 1.045807089 12.52385137
1396 0.1574788655 0.4832590392 1.055037832 10.06741705
1397 0.001798625974 0.5185788229 0.9068931676 65.36349555
1398 0.0002188657231 0.4040588267 1.018827067 21.94090529
1399 0.02311964389 0.5940560086 0.9677529808 50.66936293
1400 0.04003519247 0.463533281 1.005284984 71.29130745
1401 0.0001308739693 0.5343969245 0.9565544574 4.057580209
1402 0.001145141393 0.4491736483 1.069263502 46.13259083
1403 0.2562411203 0.5528457919 0.9172127793 26.72703521
1404 0.08924576714 0.4156732947 0.9834734237 35.72032494
1405 0.00314250501 0.5823071664 1.02849304 58.80433002
1406 0.0003876658978 0.4966201572 0.9411715673 18.53457736
1407 0.01328282314 0.5054497354 1.095370701 78.81137048
1408 0.01361505549 0.4257643133 0.9862555062 13.24347045
1409 0.0003732915359 0.5731927102 1.025611108 84.14496418
1410 0.003263912379 0.4619930057 0.9375114368 41.05314902
1411 0.08707864413 0.5391003244 1.098937085 53.51204723
1412 0.2625239242 0.479416536 1.001914771 51.38245776
1413 0.001102149974 0.5194902319 0.9600201337 21.35167368
1414 0.0001359955662 0.4078265261 1.07195098 65.91704074
1415 0.03908183207 0.5932163516 0.9146268675 9.30829782
1416 0.02402146879 0.4737547209 1.052155852 27.2733239
1417 0.0002136277608 0.5274972036 0.9096752979 45.37683711
1418 0.001842501573 0.4388805278 1.022393499 4.776391042
1419 0.151548207 0.559820245 0.9640928026 70.69765684
1420 0.05522561602 0.421272907 0.9366003886 79.36410236
1421 0.005290082348 0.5800264122 1.075369978 17.77497445
1422 0.000643876518 0.4910922254 0.9880454544 59.5166166
1423 0.008109645431 0.5076557573 1.048494615 35.13060458
1424 0.005988062195 0.4989344019 0.9021362901 67.83360185
1425 0.0005387951701 0.5030987965 1.059460618 7.557113972
1426 0.003395852158 0.4132858077 0.9725328226 47.82569123
1427 0.05159532094 0.5846336912 1.014427245 24.74178622
1428 0.1269388433 0.446873731 1.086448286 37.66238799
1429 0.001361805099 0.5552068621 0.9250223748 57.06816526
1430 0.0001993906599 0.4659064405 1.038125097 14.9940058
1431 0.01540505481 0.5320602683 0.9987697583 82.22775457
1432 0.0249680909 0.4001932384 1.036005744 61.60519195
1433 0.000126453788 0.5979825113 0.9755564643 32.87667225
1434 0.0008111464263 0.4871978696 1.08788404 76.30100534
1435 0.2189529791 0.5146767342 0.9491145695 21.00474572
1436 0.08104852871 0.4542055681 0.9516022494 1.547268266
1437 0.002087253852 0.543919926 1.009903113 73.76140235
1438 0.0003110310386 0.4334037049 0.9221879633 29.52790474
1439 0.0100104044 0.5684204467 1.06466835 43.28891026
1440 0.01079455567 0.4570029581 1.020064244 80.9731018
1441 0.0002959422442 0.5419036921 0.9680135479 13.71854154
1442 0.002575148621 0.4307284329 1.056070493 58.30470061
1443 0.0686987672 0.5703145625 0.9073399397 38.87814985
1444 0.2003494414 0.4106811054 0.9919616235 26.22732474
1445 0.0008410724267 0.5882759912 1.046160784 49.2904968
1446 0.0001047039643 0.4765878847 0.9342726612 6.219392586
1447 0.03008754697 0.5245053723 1.079292251 66.47519057
1448 0.01908483567 0.4425147485 0.9414215021 44.52576986
1449 0.0001697149234 0.5587845007 1.096597151 30.74399085
1450 0.001451022934 0.4701434003 0.983933882 72.50642533
1451 0.119341276 0.5286046524 1.029539483 0.2714797575
1452 0.04223378449 0.4900100378 1.069627829 19.66670009
1453 0.004045343031 0.5112420075 0.9185537159 74.94226982
1454 0.0004948195999 0.4223321944 1.005823309 34.36253502
1455 0.006231887801 0.5763684576 0.9576786716 63.07032176
1456 0.007596156403 0.417718826 1.09178037 8.115840107
1457 0.0006835303433 0.5843616493 0.9467609003 64.74539704
1458 0.004278444505 0.4945731118 1.033645971 22.65044462
1459 0.06500907622 0.5033937147 0.9794466916 52.70199965
1460 0.1646943286 0.4655864295 0.919829718 54.89384625
1461 0.001766955392 0.536446842 1.068560105 42.45567847
1462 0.0002614911322 0.4471220138 0.9555001076 82.70354383
1463 0.02020421296 0.5507974122 1.007550971 11.82274252
1464 0.03173923323 0.4814074986 0.9701684741 36.42969978
1465 0.000160756849 0.5167179255 1.018312897 60.83648275
1466 0.001020091204 0.4059088534 0.9060402522 16.58219249
1467 0.2753703087 0.5959153682 1.05711458 78.19213442
1468 0.1053730227 0.4354945818 1.042027532 69.25591223
1469 0.002713851683 0.5626812886 0.996422193 3.355338862
1470 0.0004071569042 0.4521894474 1.08408241 46.75896038
1471 0.01310497562 0.5496850358 0.928906499 28.67617759
1472 0.01230747404 0.4765263351 1.077974927 59.96912981
1473 0.000433368853 0.522368199 0.9354945198 36.54804704
1474 0.002889086525 0.4112046625 1.048160841 77.31438777
1475 0.09899055399 0.589850449 0.9898599986 16.71093346
1476 0.2932317071 0.4286419019 0.9123704173 3.235046105
1477 0.0009585674925 0.5703028938 1.051139867 70.12131968
1478 0.0001509417382 0.4586267186 0.9638611194 28.54549112
1479 0.03377532001 0.5424788393 1.02431042 47.63476153
1480 0.02150597693 0.4245411802 0.9620255796 64.19903046
1481 0.0002456277016 0.5767459588 1.00138094 9.240029021
1482 0.001660051692 0.4881165752 0.9133270452 52.16603184
1483 0.1753575973 0.5106435876 1.074752935 23.76423476
1484 0.06109271112 0.4704738831 1.027733808 41.32824706
1485 0.004556708245 0.5307658553 0.9858394062 55.43697034
1486 0.0007274148912 0.4418679796 1.097718373 10.70570989
1487 0.007133808187 0.5568449793 0.9403940247 83.23626915
1488 0.006639671639 0.4497452518 1.011800793 31.60875977
1489 0.0004651831277 0.5523231134 0.9513516596 44.4048389
1490 0.003796777206 0.4625462927 1.063627355 1.146642384
1491 0.04491760773 0.535432644 0.9248577388 72.37510066
1492 0.1120323087 0.4960502688 0.9773490025 75.05995829
1493 0.001543560814 0.5059706958 1.035649726 18.79868868
1494 0.00018077053 0.4166578049 0.9479803527 63.19840394
1495 0.01793684717 0.5812739279 1.09046088 33.4841299
1496 0.02829034511 0.4509308696 0.9278830998 14.26232379
1497 0.0001115641633 0.5471824383 1.085207186 79.8463295
1498 0.0008946945264 0.436385089 0.9983251672 39.41153333
1499 0.1880469703 0.5654512487 1.040219831 57.18832708
1500 0.07309424386 0.4034553723 1.062243284 50.4153236
1501 0.002417538243 0.5947081972 0.9008176088 25.68159699
1502 0.0002781884211 0.4842282873 1.013868451 67.5896186
1503 0.01149865333 0.5176584968 0.9745128769 5.684063616
1504 0.009412481227 0.4077909432 0.9156501949 32.0838892
1505 0.0003314105691 0.5911539732 1.070826085 61.81885567
1506 0.00222032025 0.4799660062 0.9581170399 20.22231585
1507 0.07607155678 0.521139431 1.0037224 76.50431589
1508 0.2329614477 0.4598805556 1.093808309 73.54968413
1509 0.000761498894 0.5390139084 0.9427339606 2.341996809
1510 0.000118868003 0.4273621131 1.030055433 43.08754521
1511 0.02659675074 0.5736930685 0.9819110315 30.3122801
1512 0.01641310871 0.4932782961 1.044244674 7.107366542
1513 0.000187448726 0.5079615153 0.9921938313 69.03365195
1514 0.001278127248 0.4193565831 1.080302657 24.28168054
1515 0.1350052114 0.5793563029 0.931572249 49.03609958
1516 0.04843533469 0.4392338779 0.966190373 55.87135765
1517 0.003612414864 0.5620531434 1.020389674 38.11537791
1518 0.0005738943044 0.4731308611 0.9084557744 81.02058872
1519 0.005627877132 0.5256294195 1.053475224 15.45735396
1520 0.008632173104 0.4684579831 0.9944227314 46.17220418
1521 0.0006048170171 0.5335631022 1.042567395 27.06224388
1522 0.004970011829 0.443761857 0.9302489744 71.48267073
1523 0.05880110326 0.5541697551 1.081323061 4.575664201
1524 0.1424180941 0.4148347078 1.016232802 17.98929696
1525 0.001962330483 0.5872335874 0.9706272272 78.57197779
1526 0.0002273437993 0.4979450703 1.058339324 35.33457392
1527 0.02255943012 0.5000339365 0.9031636486 58.73484521
1528 0.03670356483 0.4322198743 1.065985601 84.59729595
1529 0.0001447508965 0.5659437682 0.9209659852 12.04600373
1530 0.001173314703 0.4551708642 1.007902936 53.97473724
1531 0.2466224355 0.5467158468 0.9537038025 39.84532407
1532 0.09272671057 0.4846695937 0.94408402 22.55108589
1533 0.003067054997 0.5134435965 1.092814547 50.93207149
1534 0.0003505004875 0.4029392859 0.9797087733 10.51806828
1535 0.01448848847 0.5988971695 1.031759496 65.45629622
1536 0.01455946153 0.4848228743 0.9904907126 83.34915285
1537 0.0003522174329 0.5138899878 1.048010111 11.13498108
1538 0.003040195351 0.4024946101 0.9357191563 55.53421029
1539 0.09191466181 0.5987452252 1.077418508 41.77316202
1540 0.2478305656 0.4326645467 1.02483108 23.29086946
1541 0.001179062388 0.56609571 0.9636007171 52.01942241
1542 0.0001434832276 0.455017587 1.051279245 8.761388338
1543 0.03638213116 0.5462694582 0.9117283575 64.05769641
1544 0.0224494569 0.414109078 1.074589998 47.40005382
1545 0.0002262355453 0.586996383 0.9139455521 27.99422874
1546 0.0019796676 0.4981839923 1.000836727 69.90208854
1547 0.1436763484 0.5007609002 0.9622624232 2.668307149
1548 0.05851446527 0.4682190644 0.9401458295 17.22847012
1549 0.004945784638 0.5328361411 1.09825124 77.50500137
1550 0.0006101604799 0.4444874834 0.9851851394 37.07069189
1551 0.00870843673 0.5544069568 1.027860979 60.15463522
1552 0.005567697618 0.4396801235 0.9242425727 5.532276328
1553 0.0005677575721 0.5622065637 1.063793245 67.12145142
1554 0.003637213113 0.4729791578 0.9511116659 25.54546106
1555 0.0487678316 0.5251845086 1.012342243 49.93150506
1556 0.1335615698 0.493430002 1.089930972 57.62277614
1557 0.001264459904 0.5084064296 0.9482318828 39.51921891
1558 0.0001887355333 0.4189103348 1.035519786 80.28604634
1559 0.01652578272 0.5792028792 0.9780001251 14.36474159
1560 0.02688422996 0.4596432108 1.040373514 33.67994162
1561 0.0001201528282 0.5382884251 0.9976977941 63.71076275
1562 0.0007563069607 0.4280893127 1.085760843 18.97901624
1563 0.2313730993 0.5739317488 0.9276553132 75.58780127
1564 0.0768937906 0.4070637411 0.9747766141 71.81864015
1565 0.002244319069 0.5909152895 1.013350751 0.9171125339
1566 0.0003291510364 0.4802033536 0.9014565244 43.8432778
1567 0.009348307349 0.5218649177 1.062101138 31.38433051
1568 0.01157758847 0.4036073159 1.003190394 15.68169076
1569 0.0002800981176 0.5951528708 0.9583660904 81.58222202
1570 0.002391687238 0.4837818967 1.070699769 38.34497996
1571 0.07231263685 0.5175052185 0.9163053229 56.4277257
1572 0.1893378844 0.4513772635 0.9812933858 48.50818187
1573 0.0009008364963 0.5473357193 1.030219225 24.10144798
1574 0.0001103711822 0.436233142 0.9424979724 68.52138814
1575 0.02798782915 0.5650065726 1.094353383 6.911480087
1576 0.01781455295 0.4953233087 0.9318335066 30.2097673
1577 0.0001795380232 0.505731779 1.079782858 42.64790311
1578 0.001560244869 0.4168950055 0.9928367523 2.23438595
1579 0.113243248 0.5819995524 1.044106151 73.11514008
1580 0.04461136281 0.4495080478 1.053626809 76.98806223
1581 0.003770890948 0.5515974863 0.9078259217 20.35854424
1582 0.0004702111476 0.4632732561 1.020946955 62.28711531
1583 0.006711437987 0.5356715634 0.9659665918 32.23560429
1584 0.007071334068 0.4709187977 1.081840097 65.27086554
1585 0.0007210445978 0.5309175638 0.9299845668 9.995328425
1586 0.00457902966 0.4417145556 1.042708871 50.74136289
1587 0.06139197703 0.5563987285 0.9937831512 22.03362396
1588 0.1738218874 0.4246946016 0.9037903572 40.41215548
1589 0.00164551369 0.5771922063 1.05818497 54.19389618
1590 0.0002468309588 0.4876716632 0.9708543433 12.59719392
1591 0.02161132768 0.5104918825 1.01567848 84.83209611
1592 0.03407372369 0.4284032209 0.9534516018 58.87625145
1593 0.0001522752982 0.569575692 1.008432179 35.81312214
1594 0.0009538946457 0.4593522027 0.920314198 78.71849476
1595 0.2918022631 0.5427161863 1.06611487 18.46273446
1596 0.0998651199 0.4758008536 1.031592936 4.130844236
1597 0.002914611062 0.5221308554 0.9803232748 71.38535605
1598 0.000431256308 0.411443341 1.092272432 26.63289795
1599 0.01224747911 0.5905776475 0.944323343 46.05941546
1600 0.01304109313 0.4356341291 1.098794846 34.68829755
1601 0.0004051721347 0.5631139474 0.9381502541 59.42197698
1602 0.002737828052 0.4517554531 1.025093309 17.34830358
1603 0.1063039767 0.5495437723 0.986519151 79.25382658
1604 0.2740279354 0.4818414902 0.9143989885 70.84157601
1605 0.00101511844 0.5168591857 1.072504539 5.25761432
1606 0.0001621771249 0.4057693087 0.9593926622 45.52602914
1607 0.03201964816 0.5954827128 1.002068361 27.74927433
1608 0.0203031868 0.4648470672 0.9647438269 9.87764217
1609 0.0002627720997 0.5361959044 1.022263467 66.13887473
1610 0.001751481175 0.4473716166 0.9099267356 21.90553892
1611 0.1632520033 0.5515350575 1.051625846 51.61977086
1612 0.06532752665 0.4174692258 1.049035967 53.32912948
1613 0.004299402823 0.5836240074 0.9878053684 40.53308423
1614 0.0006775443662 0.4953124715 1.075535776 83.95693064
1615 0.007529633282 0.5036446489 0.9359851241 12.72852145
1616 0.006299246528 0.4904425502 1.014554324 43.77533166
1617 0.0005001679512 0.5113816952 0.9718784574 29.66664606
1618 0.004017762062 0.4221911727 1.059993386 74.23217493
1619 0.04194583768 0.5759342276 0.9018880025 1.701658415
1620 0.1206312168 0.4426557736 0.9990065094 20.90490798
1621 0.001466706766 0.5592187334 1.037580786 75.86387617
1622 0.0001685577945 0.4697108846 0.9256407835 32.77157432
1623 0.01895471441 0.528464962 1.086285257 61.17332296
1624 0.02976581305 0.4104300281 0.9484724114 81.70251193
1625 0.0001035843408 0.5875367746 1.088023325 14.81628617
1626 0.0008468462874 0.477325765 0.9752959697 56.55841438
1627 0.2017248101 0.5247547342 1.036526306 37.46917659
1628 0.06796416165 0.4562650744 1.064111832 24.96879807
1629 0.002547612272 0.5416543277 0.9224125074 48.38983746
1630 0.0002979738164 0.4309795136 1.009752291 7.78922895
1631 0.01086865737 0.5710537817 0.9522328651 68.39264495
1632 0.009942153909 0.454346831 0.9075791704 62.51134832
1633 0.000308910452 0.544353918 1.05552828 34.13033011
1634 0.002109814394 0.4329710469 0.9686279511 74.37803366
1635 0.08192455707 0.5682809016 1.019897591 19.4397579
1636 0.2174601415 0.4006258991 1.079421427 0.4647785518
1637 0.0008056159939 0.5981220597 0.9336207757 73.01610908
1638 0.0001278206067 0.4870566042 1.046689929 30.92164335
1639 0.02523796625 0.5142427389 0.9917093305 45.0510999
1640 0.01551080865 0.4461360894 1.028985063 66.90712669
1641 0.0002007594467 0.5549572645 0.9841609057 6.324403118
1642 0.001347242965 0.4661573743 1.096442705 49.72753858
1643 0.1255814572 0.5327996254 0.9420481123 26.32722961
1644 0.0519495104 0.4986834655 0.957038993 38.72384963
1645 0.003419163763 0.5023594361 1.005964692 57.83385837
1646 0.0005330337578 0.4140234519 0.9182892159 13.57973055
1647 0.005924031183 0.5848832922 1.070144767 80.48677033
1648 0.008181292624 0.4217071408 0.9792228181 29.1910392
1649 0.0006495650654 0.5801674392 1.034203154 46.94706105
1650 0.005264294918 0.4909525339 0.9461309493 3.875470785
1651 0.05495640748 0.5072232397 1.091931863 69.43874259
1652 0.1528871251 0.4738944091 1.007412356 77.95475165
1653 0.001858780005 0.5279297186 0.9561429303 16.02841717
1654 0.0002125863696 0.4384462973 1.068040208 60.61473868
1655 0.02390436838 0.5596792206 0.9200908832 35.86028576
1656 0.03873957058 0.4791671734 1.057659555 11.34670216
1657 0.0001348045728 0.5187523494 0.9058041716 82.55442146
1658 0.001107549047 0.4085657435 1.018476596 41.97452485
1659 0.2638099511 0.5934674311 0.9695507301 54.74983715
1660 0.08631605798 0.4250250993 0.9295615287 52.81220831
1661 0.00323532876 0.5729416333 1.083956002 23.07720289
1662 0.0003751201244 0.4622423649 0.9966711512 64.84012406
1663 0.01368174997 0.5398382043 1.041495428 8.55808001
1664 0.01316649959 0.4163989244 0.9260928961 70.21520646
1665 0.0003842709249 0.5825443707 1.087323259 3.30847194
1666 0.003157898739 0.4963812351 0.9992602101 47.56142436
1667 0.08968294497 0.5047227716 1.038811097 28.45151567
1668 0.2539970733 0.4637721997 1.060538531 36.64068243
1669 0.001135112715 0.5351238856 0.9030191327 60.04121305
1670 0.0001315150781 0.4484480219 1.014913359 16.63892874
1671 0.040231313 0.5526085902 0.9732140077 77.22167385
1672 0.02332390438 0.4831057586 1.010779661 55.3637117
1673 0.0002207993936 0.5181324316 0.9526742499 41.23419308
1674 0.001789858044 0.4045035025 1.065355829 83.33040165
1675 0.1567111839 0.5942079529 0.9226799898 10.77889
1676 0.0536477081 0.4369060392 0.9764377315 9.168102839
1677 0.005470304871 0.5643826034 1.037082178 64.10623801
1678 0.0006251790222 0.4504850809 0.9497942746 23.85711587
1679 0.008381893629 0.5482766302 1.088368578 52.23786936
1680 0.006170212932 0.4583167205 0.9607000295 18.87210913
1681 0.0005215537216 0.5437027436 1.002399119 75.15385046
1682 0.003493996867 0.4289263297 0.9155079439 33.3901592
1683 0.04987071404 0.5690038519 1.073027605 63.12506202
1684 0.1306075821 0.4124771081 1.026298396 44.47692689
1685 0.00131628616 0.5895928083 0.9867477234 31.7013904
1686 0.000205455865 0.4752802229 1.099813824 72.28238136
1687 0.01491208986 0.5227002144 0.9385832466 1.074643056
1688 0.02583152018 0.4407980945 1.075855901 25.58754776
1689 0.000122901732 0.5573639268 0.9372817645 50.34206021
1690 0.0008379613891 0.471567026 1.049572719 5.757238348
1691 0.2124893232 0.5303182546 0.9889281062 67.68375649
1692 0.08372781691 0.4885925127 0.9101659404 79.75353167
1693 0.002025636132 0.5095222987 1.052841661 14.19040299
1694 0.0003217869856 0.4240427479 0.9651631331 57.26016935
1695 0.009729216618 0.577795138 1.023268663 39.50440968
1696 0.01044976563 0.4976114336 1.067677453 2.413923624
1697 0.0003050003189 0.5012845309 0.918751614 73.64247594
1698 0.002489225257 0.4150970215 1.006869595 30.21939963
1699 0.07069722528 0.5859597113 0.9550141847 43.01570706
1700 0.1936644556 0.4450564167 0.9458857367 61.89211495
1701 0.0008655391768 0.5538869485 1.09071004 32.17794254
1702 0.0001013596311 0.4672355093 0.978760883 76.41018401
1703 0.03100846031 0.5338684274 1.033155329 20.14913511
1704 0.01854535295 0.401894589 0.9953455683 38.02274316
1705 0.0001755732046 0.5993939806 1.041146455 55.79927378
1706 0.001407929286 0.4857894521 0.9284221508 15.52935931
1707 0.1232789124 0.512972332 1.083402514 81.113302
1708 0.04097950252 0.4556200862 1.017241086 68.93976579
1709 0.004178819011 0.5456182217 0.9692917351 7.033940074
1710 0.0004808321027 0.4316962538 1.056622362 49.10943738
1711 0.006447001015 0.5670150839 0.9053529635 24.37565536
1712 0.007821008583 0.4270811185 1.045668757 78.66477498
1713 0.0006610512604 0.5749886772 0.9912741441 18.06121839
1714 0.004407210507 0.4601878835 1.07822025 58.6630023
1715 0.0629014034 0.5377926745 0.9333961129 35.24169819
1716 0.1696509981 0.4812155517 0.9675290089 27.15629247
1717 0.001709668206 0.5208039824 1.019384539 46.2454682
1718 0.0002692315468 0.4065158274 0.9062635057 4.502488836
1719 0.01953976639 0.5914142841 1.055189226 71.38853347
1720 0.03280274545 0.472035048 0.9178677166 50.85998286
1721 0.000156060034 0.5260796905 1.069137377 22.45845588
1722 0.001054779208 0.4403071962 0.9568036987 65.54901489
1723 0.2674534125 0.5615307627 1.004752788 10.59006824
1724 0.1089562411 0.4198523451 1.095915966 11.97258265
1725 0.002635828999 0.578309794 0.9409353884 84.50340441
1726 0.0004207997278 0.4928057918 1.028656641 39.93929413
1727 0.01272208634 0.509079371 0.9828559687 54.0480798
1728 0.01195582489 0.4671502646 1.034963912 21.25904146
1729 0.0004481328495 0.5317580068 0.9768583614 51.31037135
1730 0.002805190412 0.4455577971 1.089585717 9.380300632
1731 0.1023137603 0.5554866288 0.9469100177 66.00975655
1732 0.2847164993 0.4130326612 0.9506702822 84.05107043
1733 0.0009907472416 0.5859228142 1.011314875 13.17005158
1734 0.0001466290614 0.4992588952 0.9239750914 53.58539264
1735 0.03492598593 0.5018329313 1.062549249 41.14711624
1736 0.02080745613 0.4339303652 0.9003253961 17.84689366
1737 0.000252973862 0.5673705053 1.061555994 79.45690177
1738 0.001605359944 0.4537532825 0.9734410657 35.03773171
1739 0.1805152368 0.5449962007 1.012991717 59.44477085
1740 0.05907997458 0.486093282 1.084722839 45.45009892
1741 0.004690731977 0.5151571421 0.9272031995 27.36737471
1742 0.0007037880831 0.4012226885 1.039143202 70.60352243
1743 0.007347162033 0.5974765331 0.9974440923 4.703212827
1744 0.006859164957 0.4091168888 1.050063428 56.99608424
1745 0.0004514504655 0.5929652078 0.9114891516 37.56975038
1746 0.003928075671 0.4781517198 1.023825883 82.32046564
1747 0.04365589352 0.5198165372 0.9631814098 15.06601336
1748 0.1159065361 0.4616887415 0.9344225178 7.483690353
1749 0.001500202523 0.5403429087 1.077098384 67.73971284
1750 0.0001867464554 0.4260422681 0.9893679766 24.83575881
1751 0.01740733852 0.5718757274 1.04747336 47.89903125
1752 0.0291079812 0.491573873 0.9849565681 73.85419702
1753 0.0001078350849 0.5065531723 1.026655893 1.619192231
1754 0.0009219100003 0.4207679778 0.9397128381 43.21706989
1755 0.1820294228 0.5810576743 1.097232264 29.43502648
1756 0.07531769387 0.4378285836 1.000505968 32.97072844
1757 0.002340177075 0.5603456656 0.9609550539 61.67844838
1758 0.0002862284503 0.4748291837 1.074066931 20.93156276
1759 0.01111430309 0.527043869 0.9128365949 76.20687569
1760 0.009132943953 0.4484345144 0.9711133365 49.21723562
1761 0.0003423454617 0.5505210787 1.016913988 26.13327329
1762 0.002157556586 0.4643452756 0.9042415634 66.56932561
1763 0.07869740355 0.5367464332 1.059222162 6.292570168
1764 0.2263761773 0.4942451853 1.043057845 13.64662296
1765 0.0007877846121 0.5046630131 0.9951087352 80.88030175
1766 0.0001153377686 0.4179746429 1.082393586 38.97102336
1767 0.02747430323 0.5830698561 0.9311239459 58.37654573
1768 0.01586545905 0.4526444033 1.093494257 75.03616421
1769 0.0001929015933 0.5486060908 0.9445685575 19.74011832
1770 0.001237302746 0.4349644883 1.032640762 62.99697699
1771 0.1391374268 0.5637346633 0.9807852117 34.26856717
1772 0.04688825794 0.4048820736 0.9216534661 30.8366237
1773 0.003722982014 0.5964186762 1.066477624 44.59785563
1774 0.0005547455176 0.482508653 0.9545803463 0.1994775794
1775 0.005791593147 0.5162409509 1.008974939 72.41370888
1776 0.008925710603 0.4778553711 0.9436106952 42.36162164
1777 0.0005874286684 0.5241763968 1.094880121 54.82059046
1778 0.00513654482 0.4093873095 0.9825983217 11.89592485
1779 0.05708310433 0.5885305682 1.030547646 82.79767412
1780 0.1471902083 0.4304531485 1.07170716 64.65260175
1781 0.001904997348 0.5716288751 0.9167268241 8.043916775
1782 0.0002350745881 0.4573037891 1.004402301 52.77383939
1783 0.02191084587 0.540664541 0.9586013867 22.74332351
1784 0.0378082029 0.4228336904 1.021460008 3.428761847
1785 0.0001400578641 0.5753406288 0.9670655351 69.34980187
1786 0.001208046026 0.4895310605 1.053965864 28.58220436
1787 0.2385118851 0.5123419221 0.9091415875 46.68562099
1788 0.09547149668 0.4690655043 0.9932719368 60.90856314
1789 0.002966189476 0.5290614203 1.045127321 36.52233801
1790 0.000361049298 0.4435693629 0.9320581675 78.09942272
1791 0.01401875458 0.5582564099 1.080984034 16.51018556
1792 0.01433025683 0.4432559457 1.016462523 58.13782995
1793 0.0003690716201 0.557847994 0.9716384334 39.0434094
1794 0.002993808407 0.4695242735 1.058966009 80.80596515
1795 0.09636035933 0.5294190887 0.9045713479 13.88341857
1796 0.2365419253 0.4890727652 0.9945592245 6.052228077
1797 0.001198067191 0.5119839646 1.043484897 66.6400752
1798 0.0001368801809 0.4231473967 0.9307697477 26.06054274
1799 0.03695036096 0.5757485708 1.082625325 49.45564741
1800 0.02209323896 0.4576281855 0.9450932711 72.670917
1801 0.0002370316419 0.5410831492 1.093042408 0.1040799776
1802 0.001949229411 0.4299811352 0.9811146129 44.69003608
1803 0.1506079628 0.5712571757 1.032384226 30.57616802
1804 0.05584247948 0.4098598026 1.066905058 34.52673283
1805 0.005024913616 0.5889019845 0.921104338 62.90254707
1806 0.00058200722 0.4775312578 1.009207061 19.83132095
1807 0.008843342741 0.5237573087 0.9542265307 74.77472058
1808 0.005654660735 0.4820517994 1.095136275 22.81505614
1809 0.0005416289904 0.5158783091 0.9432809122 52.53448002
1810 0.003695843765 0.4051913103 1.030999113 8.280069116
1811 0.04654642625 0.5968282267 0.9820732262 64.57761142
1812 0.1400217813 0.4346557314 0.9170810208 82.86778043
1813 0.001245165883 0.5633248296 1.071475419 11.65492903
1814 0.0001977670061 0.45310154 0.9591508958 55.05834884
1815 0.01626560543 0.5489682527 1.003975247 42.2882475
1816 0.02730067542 0.4184424756 0.9667361325 16.41544136
1817 0.0001146089827 0.5834426902 1.021716543 78.35727443
1818 0.0007684066834 0.4939227045 0.9086168723 36.26252561
1819 0.2208079893 0.5042394316 1.054417712 61.0013973
1820 0.08060343693 0.4646682303 1.0448952 46.59183434
1821 0.00220981413 0.5371697256 0.9936257539 28.84102375
1822 0.000344857952 0.4479669707 1.080556601 69.08901165
1823 0.009199980274 0.5501477707 0.932607297 3.520608065
1824 0.01104407536 0.4744715011 0.9772121785 40.88796753
1825 0.00028441958 0.526585108 1.034731792 53.67883984
1826 0.002282615536 0.4382369898 0.9474591473 13.07851441
1827 0.07346503116 0.5606590984 1.089158284 84.31217983
1828 0.1864383095 0.4203600515 1.011571409 65.75223416
1829 0.0009442384246 0.5807439582 0.9503408795 9.475384275
1830 0.0001086265972 0.4919318387 1.063001096 51.21722814
1831 0.02932160699 0.5070114534 0.9234503763 21.51853468
1832 0.01699575501 0.4264139578 1.061324254 4.943869193
1833 0.0001823311572 0.5723477563 0.9006795928 70.5330868
1834 0.00148926557 0.4612701191 1.012564664 27.44106804
1835 0.1150616453 0.5400185205 0.9739905749 45.21264958
1836 0.04393332816 0.4785708161 0.9268734165 59.68446967
1837 0.003953042553 0.5201406363 1.084978994 34.9663284
1838 0.0004628366148 0.4087454882 0.9969189968 79.53157291
1839 0.007032168342 0.592492705 1.039594669 17.61043227
1840 0.007408329188 0.4008131282 0.9109400235 47.99313186
1841 0.0007096466255 0.597167312 1.050490863 24.5772537
1842 0.004799650561 0.4864559095 0.9628275942 68.00146552
1843 0.06045175212 0.5156140039 1.024058005 7.392806909
1844 0.176592151 0.4533911288 1.076646535 15.16174028
1845 0.001570469548 0.5445390498 0.9349472314 82.06359697
1846 0.0002506393719 0.4343402145 1.047216824 37.82989701
1847 0.02061542228 0.5676792525 0.9896973778 56.90358461
1848 0.03570202157 0.4996824626 1.027082944 76.13578665
1849 0.0001498872215 0.5021554204 0.9844070574 21.17157553
1850 0.0009999713671 0.4126598174 1.097464003 61.44035576
1851 0.2873675571 0.585454997 0.9393586399 33.04376804
1852 0.1014686139 0.4459311208 0.9614801509 29.36297989
1853 0.002782021367 0.5559541628 1.000054502 43.45611499
1854 0.0004379650386 0.4667269804 0.9131663794 1.382077434
1855 0.01168456648 0.531435038 1.073810778 73.92822457
1856 0.01244517272 0.4924325792 0.9193011187 20.05520169
1857 0.0004116400712 0.5086119227 1.067250396 76.66917044
1858 0.002611435404 0.4202755421 0.9553683769 31.91699543
1859 0.1079477847 0.5786326533 1.00663785 61.98413833
1860 0.2696892983 0.4398835193 1.091161512 42.9207857
1861 0.001063596065 0.5612081865 0.9453606457 30.47740824
1862 0.0001596880108 0.4724079775 1.033411488 73.3824965
1863 0.03356528868 0.5265476186 0.9784311045 2.506904555
1864 0.0193778443 0.4068780847 1.040719015 24.44592871
1865 0.0002670007222 0.5918715162 0.9958946904 48.8682948
1866 0.001670819584 0.4808056226 1.083170386 7.271875627
1867 0.1657962009 0.5204951301 0.9287759604 68.86623475
1868 0.06430075631 0.4605973387 0.9687670274 81.18519153
1869 0.004505260928 0.5381018158 1.017692941 15.28982277
1870 0.0006672287423 0.4267185722 0.9050235683 56.03557289
1871 0.007894103061 0.574531919 1.056878904 37.9475858
1872 0.006603328498 0.4312772611 0.9909199534 71.64687662
1873 0.0004924909017 0.566691066 1.045900504 4.407901699
1874 0.004209636352 0.4559914071 0.9328466097 46.33683818
1875 0.04128167214 0.5460906195 1.078647309 26.89470177
1876 0.1224966732 0.4854176573 1.019128378 35.4990534
1877 0.001398994308 0.5125002233 0.9678587859 58.56743735
1878 0.0001712487387 0.4023132926 1.054737753 18.15355605
1879 0.0180885525 0.5997184724 0.9067885952 78.40414182
1880 0.03120659279 0.4676435467 1.069369504 53.80758049
1881 0.0001020073771 0.5341822291 0.9175139055 40.0102212
1882 0.0008873928662 0.4446983637 1.005180227 84.43052677
1883 0.1985544127 0.5534285579 0.956254575 12.21116179
1884 0.06902327364 0.4154545946 0.9412647851 10.35118511
1885 0.0024302882 0.5864183851 1.095659425 65.62154801
1886 0.0003027686648 0.4972031131 0.9833806779 22.3839418
1887 0.0103733162 0.5009712091 1.028204788 51.0969357
1888 0.009791392169 0.4237198744 1.087066718 77.14944978
1889 0.0003238430746 0.5773719491 0.9264222927 16.87813106
1890 0.002076782646 0.4890599513 1.038359244 59.8039309
1891 0.0858418332 0.509895527 0.9997849192 36.71485706
1892 0.2074582478 0.4710991135 0.9026653215 28.38027955
1893 0.0008181203195 0.5299453154 1.060770658 47.80160448
1894 0.0001220025916 0.4411206789 0.9726648841 3.070222111
1895 0.02564251452 0.5577875895 1.015340798 70.28842355
1896 0.0152736648 0.4755890654 0.953004027 52.3337535
1897 0.0002104377843 0.5231101591 1.0105235 23.60006971
1898 0.001325992068 0.4120198619 0.9232050793 64.36653172
1899 0.1315707638 0.5892305592 1.064904356 9.075435866
1900 0.04955422385 0.4293830961 1.037313925 10.87315795
1901 0.003471826583 0.5693663841 0.9760835407 83.07174945
1902 0.0005087070696 0.4580075948 1.088795638 41.49612324
1903 0.006018236969 0.5432932787 0.9492447713 55.27267104
1904 0.008312442378 0.4500126734 1.002850973 1.31448864
1905 0.0006199982714 0.547905325 0.9601753218 72.21081101
1906 0.005346008855 0.4372300429 1.073284147 31.77621844
1907 0.05242867809 0.5648016043 0.9151785487 44.24028833
1908 0.1601976565 0.4041790189 0.9872968456 63.36589555
1909 0.001829676546 0.5937892351 1.025870956 33.31956666
1910 0.0002228629592 0.4835778829 0.9389370563 75.22771082
1911 0.02354186548 0.5185042167 1.099581696 18.63451303
1912 0.03935558642 0.4489063984 0.9367566735 39.24672026
1913 0.0001286524762 0.5529666513 1.076307373 57.35539977
1914 0.001124606588 0.4634583883 0.9885983277 14.09708261
1915 0.2516464195 0.5347158639 1.049828878 80.01318179
1916 0.09043259845 0.4966945726 1.052414603 67.42445088
1917 0.003184298576 0.5051310824 0.9107154451 5.850862712
1918 0.0003932038228 0.4159402588 1.023036918 50.25037627
1919 0.01347258496 0.5821867835 0.9655173253 25.8488242
1920 0.01379607526 0.4618690569 1.055980129 44.95796176
1921 0.0003782543002 0.5393706607 0.9070544563 31.18111124
1922 0.003310554155 0.4254483918 1.020154127 72.75856135
1923 0.08832292484 0.573264588 0.9682985496 0.5598672619
1924 0.2580687554 0.4081421619 0.9341699034 19.3482562
1925 0.00108344486 0.5931449503 1.078993993 74.63912786
1926 0.0001335564959 0.4795400076 0.9920631457 33.8711662
1927 0.03838086629 0.5192201821 1.046457807 62.60483099
1928 0.02443625696 0.4388084592 0.9836358091 80.56141614
1929 0.0002173167598 0.5601363573 1.029436529 13.34327423
1930 0.001876142995 0.4734845754 0.9417183282 58.07356226
1931 0.1543154083 0.5276209617 1.096698858 38.65242098
1932 0.05450078594 0.4913620844 1.005537641 26.40090773
1933 0.005220655665 0.5075324764 0.9575885041 49.4901247
1934 0.0006348074955 0.4213444991 1.069913028 6.565094949
1935 0.007995428313 0.5797105856 0.9186434144 66.83667586
1936 0.005886419163 0.4136043638 1.03394662 36.12039693
1937 0.0005296489977 0.5845591789 0.9795522211 60.52225425
1938 0.003334960537 0.4990548817 1.091480016 16.12415928
1939 0.05067010857 0.5028319292 0.9466556648 77.69784752
1940 0.1286270572 0.4657856749 0.9557891136 69.7004902
1941 0.001379915031 0.5323276121 1.007644477 3.784612673
1942 0.000202239209 0.4465546977 0.919541754 47.04118699
1943 0.01562512046 0.5552816609 1.068467641 28.93252901
1944 0.02464048155 0.4874645462 0.9061339542 8.320980412
1945 0.0001247946935 0.5145564452 1.057403401 64.91411614
1946 0.0007997183483 0.4002679415 0.9700758252 23.00512083
1947 0.2158683977 0.5976637645 1.018025129 53.0512686
1948 0.08244771086 0.4333287153 1.084187742 54.51176987
1949 0.002123289177 0.5687396707 0.9292073317 42.04755939
1950 0.0003167112261 0.4539384151 1.041922481 82.48332736
1951 0.01019322875 0.5440405007 0.9961216416 11.58674027
1952 0.0106113626 0.4306565447 0.937796057 27.67657924
1953 0.0002909195628 0.5706304975 1.099026587 45.76442573
1954 0.002528964429 0.4567326084 0.9859696414 5.01725703
1955 0.06746662073 0.5420276513 1.025520362 70.91236107
1956 0.203013175 0.4768579479 1.072248384 79.17949505
1957 0.0008522540524 0.5243818903 0.9147287712 17.58507386
1958 0.0001062002117 0.4107525172 1.001616894 59.18323587
1959 0.03051747639 0.5879603419 0.9599177573 34.76068866
1960 0.01883435156 0.4700196318 1.022495588 12.81970887
1961 0.0001674876162 0.5288748113 0.9643900102 83.69552248
1962 0.001430585057 0.4421986228 1.052053279 40.79128536
1963 0.1176604466 0.5588565797 0.9093776064 53.23468436
1964 0.04296306729 0.4226480344 0.9881347714 51.71192597
1965 0.004115200904 0.5762968551 1.048779432 21.64508831
1966 0.000503854112 0.4901333291 0.9365098396 66.39608792
1967 0.006345676967 0.510972135 1.075083929 9.782219236
1968 0.007697180017 0.4948399687 0.9724279685 61.41107628
1969 0.0006926201722 0.5032732483 1.014127272 32.69822551
1970 0.004339568042 0.417793325 0.902242201 75.93400782
1971 0.06593775747 0.5840431036 1.059761647 20.6639071
1972 0.1618987034 0.4470472284 1.038032252 1.937775291
1973 0.001736960295 0.551116435 0.9984814128 74.1571998
1974 0.0002568023807 0.4653190961 1.08654141 29.73839389
1975 0.01984191613 0.5365675941 0.9253109993 43.53593683
1976 0.03228717538 0.4062275898 1.08759589 68.13188006
1977 0.0001635322888 0.5958406786 0.9490215391 7.881070101
1978 0.001038720193 0.4815277742 1.036294184 48.29604574
1979 0.2803994154 0.5164512593 0.9756497849 25.22764279
1980 0.1039904229 0.452068886 0.9218877934 37.20937938
1981 0.002678245821 0.5499521784 1.06456368 56.65121308
1982 0.000401420505 0.4351753682 0.9519034635 14.72150651
1983 0.01292035286 0.5627562648 1.010008826 81.96037883
1984 0.01214636874 0.4111300191 0.9578169687 6.673245458
1985 0.0004276956365 0.590169327 1.003617835 68.59456975
1986 0.002848472484 0.4762595274 0.9159515137 24.03017639
1987 0.09759887544 0.5224884285 1.070931897 48.74837719
1988 0.2982850902 0.4588938121 1.029767371 56.19046888
1989 0.0009750859368 0.5423581334 0.9818180939 38.41914952
1990 0.000153693756 0.4287170226 1.094096841 81.50999288
1991 0.03439109009 0.5699837293 0.942827368 15.9209184
1992 0.02114155401 0.487996155 1.080209915 32.49749898
1993 0.0002414657198 0.5109105861 0.9312840015 62.19608985
1994 0.00163033325 0.424222493 1.044337896 20.4528274
1995 0.1722184917 0.5768204115 0.9924825598 76.72937457
1996 0.06190325945 0.4421869533 0.9083510123 73.37542872
1997 0.004617168906 0.5567700494 1.053175337 2.141744308
1998 0.0007377837 0.4705947798 0.96629637 42.74381257
1999 0.00723550261 0.5304985711 1.020690795 29.95271608
2000 0.006754121628 0.4628164979 0.9303383775 84.90593114
2001 0.0004732011685 0.5353090171 1.08160797 12.35960288
2002 0.003865986497 0.4498171892 0.9943322744 54.43473478
2003 0.04573634227 0.5520069415 1.042281432 40.34153762
2004 0.1105653794 0.4165861532 1.058441511 22.10843679
2005 0.001523348297 0.5815896234 0.9034609601 50.5047598
2006 0.0001782299845 0.4957805408 1.016130333 10.23520947
2007 0.01768474593 0.5060940363 0.9703296337 65.19927999
2008 0.0286655782 0.4367010701 1.008200433 45.96773659
2009 0.0001130440203 0.5653795021 0.9538057929 26.89414905
2010 0.0009074512579 0.4510546872 1.065687812 71.12602511
2011 0.1907283604 0.5469120424 0.9208637016 4.224473666
2012 0.07185592216 0.4841047561 0.9799934981 18.36944954
2013 0.002376583898 0.5179284155 1.031849097 78.97812968
2014 0.000273207216 0.4031398676 0.9437982539 35.55541751
2015 0.01129277091 0.5947796581 1.092723905 58.97151733
2016 0.009574693831 0.4798457664 1.048266272 63.7977423
2017 0.0003371216982 0.5214062521 0.9901609359 8.854364203
2018 0.002260801027 0.4074720519 1.077869981 51.92449598
2019 0.07745841712 0.591228627 0.9351940671 23.5489034
2020 0.229912001 0.4276812909 0.9639549082 41.5122301
2021 0.0007515302282 0.5736179374 1.024599334 55.62619821
2022 0.0001171969729 0.460001272 0.9122778611 11.04101221
2023 0.02622283186 0.5387468016 1.050852186 83.60815448
2024 0.01663086786 0.4192821199 0.9136161551 60.39092926
2025 0.0001899358659 0.5796750035 1.074846539 36.99555987
2026 0.001296346245 0.4930112842 0.9617377136 77.57691624
2027 0.1369297646 0.508081946 1.00128858 16.98892852
2028 0.04761457159 0.4733981587 1.098019113 2.906207237
2029 0.003551203864 0.5255085124 0.9404996403 69.8285727
2030 0.0005636205824 0.4393088182 1.02743354 28.06451729
2031 0.005527133546 0.5617341563 0.9857342627 47.15887578
2032 0.008519146124 0.4440780185 1.063341773 14.45706405
2033 0.0005968971711 0.5540978311 0.9247676633 80.02544864
2034 0.004900162794 0.4685815966 1.012086084 39.77660958
2035 0.05797465058 0.5332929075 0.9514414441 57.52719599
2036 0.1448730489 0.4978217432 0.9476823777 50.02284971
2037 0.001996154535 0.500303654 1.090358029 25.28387542
2038 0.0002314878372 0.4145190228 0.9776459325 67.37979964
2039 0.02297062334 0.5873052256 1.035751531 5.437663859
2040 0.0360817407 0.4554412497 0.9982225021 31.30985189
2041 0.0001422986908 0.5465920426 1.03992166 44.08021543
2042 0.001152305898 0.4322916076 0.9279847087 0.6782142073
2043 0.2422067682 0.5656277975 1.085504301 71.89120873
2044 0.09395659348 0.4028678384 1.013778192 75.5149287
2045 0.003107737965 0.5992126638 0.9742274923 19.21757005
2046 0.0003554980352 0.4843996854 1.062333266 63.47023811
2047 0.01469508376 0.5135671142 0.9011027152 33.75087376
2048 0.0147264892 0.4442805275 0.9545307659 74.30264808
2049 0.000356258124 0.5546643874 1.008925427 1.751157488
2050 0.00311363512 0.4680129362 0.921603955 43.68106592
2051 0.09413497266 0.5330925025 1.066428044 29.55144677
2052 0.2427256719 0.4983904036 1.032690416 32.84330394
2053 0.0011547757 0.500504059 0.9808348387 61.22415956
2054 0.0001425679643 0.4143165138 1.093543885 20.80930471
2055 0.03615005311 0.5867386693 0.9446182121 75.74742041
2056 0.02292719409 0.4548350191 1.082345552 56.46463518
2057 0.0002310499558 0.5464047909 0.9310759386 37.35478777
2058 0.001991890919 0.4324828587 1.043009837 81.77347161
2059 0.1445634744 0.5662300287 0.9950607004 14.86659571
2060 0.05786495836 0.4026765872 0.9042897148 7.694112216
2061 0.004890886665 0.5986104326 1.059270245 68.27699966
2062 0.0005956231022 0.4850059161 0.9711614186 25.04101422
2063 0.008500954009 0.513754366 1.016962139 48.44148452
2064 0.005538945799 0.4804366056 0.9321062742 17.39845099
2065 0.0005648256571 0.5215844782 1.081032161 79.32494839
2066 0.003557942527 0.4072963113 0.9933200637 34.5737466
2067 0.04770496916 0.5906353023 1.045175427 59.3283599
2068 0.1372231229 0.4278570315 1.053917881 45.57751408
2069 0.001299124777 0.5742112622 0.9090935295 27.82165261
2070 0.0001902952838 0.4594104327 1.02141195 70.7257686
2071 0.01666235455 0.5385685755 0.967017551 5.162659711
2072 0.02617325384 0.419070323 1.004451904 21.79050176
2073 0.0001169752836 0.5790933181 0.9586510643 51.525343
2074 0.0007499250236 0.4935893517 1.071756839 9.927303367
2075 0.2294207095 0.5082973609 0.916776428 66.20918577
2076 0.07731186021 0.4728200912 0.982548786 83.84063701
2077 0.002256521275 0.5252930975 1.03049809 12.63275606
2078 0.0003364021165 0.4395206152 0.9435611393 53.38012821
2079 0.009554247659 0.5623158418 1.094830586 40.60465173
2080 0.01131558746 0.4629916916 1.03909367 3.971235543
2081 0.0002737594805 0.535902844 0.9973945327 69.55503685
2082 0.002380789127 0.4492269922 1.084673281 29.11947106
2083 0.0719831358 0.5518281179 0.9271536674 46.89606296
2084 0.1911125331 0.4171763502 0.9734906718 60.70916591
2085 0.0009092799503 0.581768447 1.013041392 35.97532356
2086 0.0001132447478 0.4956053471 0.9003750715 77.88443999
2087 0.02871650585 0.5055002093 1.061605601 15.9787566
2088 0.01765343323 0.4361225035 0.923927105 41.90214594
2089 0.0001779142399 0.565164637 1.062501194 54.69835284
2090 0.001520283174 0.4512670787 0.9506222265 11.44165614
2091 0.110342806 0.5474930827 1.011266887 82.67022951
2092 0.04565547023 0.4838923646 1.089633821 64.76900161
2093 0.003859146888 0.5173473753 0.9469581483 8.50793323
2094 0.0004722479155 0.4037184343 1.035012042 52.90582475
2095 0.006740509171 0.5949945232 0.9769064644 23.19175447
2096 0.007250121626 0.4116996584 1.074115085 74.49367959
2097 0.0007392750652 0.5903687082 0.9128846748 19.534874
2098 0.004625338722 0.4760561347 1.000554047 62.45970189
2099 0.06201285291 0.5219228005 0.9610032076 34.05811332
2100 0.1725653811 0.4590972047 0.939664807 31.03603281
2101 0.001633618692 0.5429237613 1.097184253 45.14487848
2102 0.0002418944802 0.4281473832 0.9849085571 0.4144696472
2103 0.02117911438 0.5697843481 1.026607861 72.94514876
2104 0.03433019706 0.4878059305 0.9894176275 49.67670261
2105 0.0001534214787 0.5103073789 1.04752299 26.25549935
2106 0.0009731239704 0.4248277923 0.9344721485 67.02358308
2107 0.2976846279 0.5770085439 1.077148036 6.420005751
2108 0.09742629888 0.441581654 1.0237763 13.53023211
2109 0.002843433037 0.556581917 0.9631319009 80.41629654
2110 0.0004268340534 0.4707850043 1.05001392 38.83904955
2111 0.01212188859 0.5311017783 0.9114395689 57.92812348
2112 0.01289591893 0.4950302469 1.056574291 25.47050842
2113 0.0004006617533 0.5038764019 0.9053048177 49.87740649
2114 0.00267252149 0.4171880674 1.01719294 5.624616044
2115 0.1037682587 0.5838549295 0.969243663 67.23468574
2116 0.2798684789 0.447652486 0.9284701547 80.21235016
2117 0.001036754365 0.5513046091 1.083450538 14.31198055
2118 0.0001631831535 0.465128818 0.9953935923 57.71377833
2119 0.03221827422 0.5359644406 1.041194458 39.63119677
2120 0.01988433055 0.4056580041 0.9787112564 19.07216673
2121 0.0002573510803 0.5956412436 1.033105682 75.7015218
2122 0.001740258792 0.4817312086 0.9458360899 33.60579976
2123 0.1622059951 0.5170168456 1.090660414 63.6571504
2124 0.06607911711 0.4518654516 1.006919099 43.93509076
2125 0.004348867207 0.5493865922 0.9550637625 31.49679458
2126 0.0006939311568 0.4357449539 1.067727032 71.74575476
2127 0.007711741802 0.5629556997 0.9188011181 0.8648377098
2128 0.006333676534 0.431235153 1.028706195 55.48076007
2129 0.0005029017437 0.5708453208 0.9829054959 41.69885803
2130 0.004106405306 0.4565202706 1.095965494 83.46303551
2131 0.04287128137 0.5414465575 0.9409849431 11.22796946
2132 0.1174376565 0.4770702858 0.9567540273 8.709275639
2133 0.001427877605 0.5249629842 1.004703185 63.98464889
2134 0.0001671300364 0.4101739088 0.9178181145 23.40349565
2135 0.01879415887 0.5877455186 1.069087707 52.11107325
2136 0.03058271108 0.4698444799 0.9063115543 70.01516073
2137 0.0001064271255 0.5282809427 1.055237206 2.760808989
2138 0.0008538724877 0.4427888734 0.9675769882 47.34579313
2139 0.203398504 0.5590353496 1.019432587 27.91943822
2140 0.067611258 0.4220577838 1.078172128 37.18250762
2141 0.002534383691 0.5761180852 0.9333480177 60.24579953
2142 0.0002914702125 0.4903084811 1.045620661 17.17554695
2143 0.01063143753 0.5115660036 0.9912260214 77.43146732
2144 0.01017517571 0.4138162024 0.9497461556 50.65019794
2145 0.0003161506066 0.5851408226 1.08832048 21.92180886
2146 0.002119013881 0.4984768679 0.9763896326 65.34439896
2147 0.08228177889 0.5026164606 1.037034058 10.04825222
2148 0.2154863858 0.4663636887 1.065403881 12.50469145
2149 0.0007983038871 0.5325430807 0.9227279669 84.71902455
2150 0.000124543238 0.446342859 1.010827637 40.48694537
2151 0.0245908556 0.5547000172 0.9527223008 54.24815751
2152 0.0156566978 0.4868737487 1.014863685 78.79154164
2153 0.0002026477278 0.5143781774 0.9731644079 18.51484779
2154 0.001382358691 0.4004437357 1.060488932 58.78459997
2155 0.1288547169 0.5982570356 0.9029694591 35.70049658
2156 0.05077224302 0.4331529211 0.9993097611 26.7072013
2157 0.003341679542 0.5681463996 1.038860627 46.11286632
2158 0.0005305897261 0.4545292126 0.926142427 4.03785523
2159 0.005896868613 0.5442187686 1.087372811 71.27147402
2160 0.007981267761 0.4624753412 0.9652126394 38.23251652
2161 0.0006336838048 0.5395578587 1.023318238 56.3359121
2162 0.005210143746 0.4252571823 0.910215516 15.73396622
2163 0.05439109918 0.5726623151 1.052891168 81.65510678
2164 0.1540423238 0.4083333714 1.049523096 68.40766823
2165 0.001872824662 0.5937472232 0.9888784558 6.818328956
2166 0.0002168788766 0.4789337233 1.075806252 48.56179486
2167 0.02438704232 0.519032984 0.9372321416 24.17558921
2168 0.0384584315 0.4386060039 1.099861825 2.287147623
2169 0.0001338262771 0.5595697474 0.9386312744 73.18883562
2170 0.001085363508 0.4740532774 1.026346423 30.09779008
2171 0.2585255167 0.527821325 0.9867957236 42.55690028
2172 0.0885009551 0.4907933824 0.9154598696 62.34121451
2173 0.003317223989 0.5073321132 1.072979462 32.3105563
2174 0.0003789261311 0.4215469545 0.9606518859 76.87482854
2175 0.01382056577 0.5802771956 1.002351044 20.26620389
2176 0.01349815015 0.4505937211 0.9183388455 82.25017488
2177 0.000393950331 0.548117712 1.070194423 15.0163319
2178 0.003191103865 0.4370151704 0.9570886487 57.09049183
2179 0.09062595199 0.5642230421 1.006014321 37.68480781
2180 0.252122613 0.4043938914 1.096393192 24.76421158
2181 0.00112673577 0.5943677973 0.9419985315 47.84801226
2182 0.0001289281013 0.4829968352 1.028935482 7.579435478
2183 0.03943993946 0.5182918297 0.9841113927 67.85602674
2184 0.02349158206 0.4487275822 1.046738009 43.31066671
2185 0.0002223867306 0.5523764499 0.9917574793 29.54959769
2186 0.00182621728 0.4640522078 1.079469577 73.78309547
2187 0.1598946273 0.534891062 0.9336688567 1.569024553
2188 0.05231676979 0.4961007532 0.9685799442 21.0264971
2189 0.005334592781 0.5049558843 1.019849557 76.32270337
2190 0.00061882519 0.416119075 0.9075311374 32.89837043
2191 0.00829670672 0.5827769849 1.055480274 61.62694317
2192 0.006029657003 0.4239080023 0.9966230936 9.329970828
2193 0.000509672864 0.5779772559 1.041447445 65.93881713
2194 0.003479246359 0.4884567486 0.9295135465 21.37345055
2195 0.04966017552 0.509705295 1.083907945 51.40413029
2196 0.1318197368 0.4717023162 1.018524721 53.53372531
2197 0.001328502527 0.5301355474 0.9695988342 41.07492035
2198 0.0002108886262 0.440932551 1.05770766 84.16673598
2199 0.0153064017 0.5571822828 0.9058522973 13.26514805
2200 0.02558774429 0.475023433 1.067990651 35.15295126
2201 0.0001217418883 0.5229067739 0.9200413471 59.53901632
2202 0.000816573546 0.4122192476 1.007362819 17.79737432
2203 0.2070658206 0.5898001911 0.9560933726 79.38644888
2204 0.08565860498 0.4291837104 0.9461806295 70.71999845
2205 0.002072347804 0.5687967522 1.091981469 4.798795828
2206 0.0003232303402 0.4585732272 0.9792724231 45.39924205
2207 0.009772856822 0.5434966639 1.034252834 27.29566535
2208 0.01039167119 0.4318794848 1.075585453 11.80034248
2209 0.000303304686 0.5668823216 0.9360347329 82.68119746
2210 0.002435198491 0.4558041628 1.049085575 42.43333163
2211 0.06916279816 0.5454843843 0.9878550449 54.87144669
2212 0.1989069773 0.4856049016 0.9098771757 52.67959455
2213 0.0008889694204 0.5131064584 1.051576312 22.62810332
2214 0.0001022128444 0.4017110689 0.964694293 64.72305527
2215 0.0312694802 0.5995272167 1.022213906 8.09343548
2216 0.01805215659 0.4674431343 0.9594407901 28.65440088
2217 0.0001709040067 0.5336135732 1.002116463 46.73728769
2218 0.001396517242 0.4452649275 0.9144470904 3.333666013
2219 0.1222796633 0.5536310624 1.072552668 69.23413568
2220 0.04119851115 0.4148880308 1.025045254 78.17036277
2221 0.004201152126 0.5862158805 0.986471165 16.56051473
2222 0.0004916200681 0.4974035256 1.098746861 60.81480483
2223 0.006591646051 0.5015398649 0.9381022003 36.40792829
2224 0.007908071224 0.4926479986 1.009704281 66.4534973
2225 0.0006684100033 0.5091899827 0.9521848343 6.197636458
2226 0.00451436361 0.4196938522 1.064063802 49.26874019
2227 0.06443073466 0.5784208639 0.9223644983 26.20563194
2228 0.1660905982 0.4404652093 0.975344047 38.85645151
2229 0.001673787985 0.5614199759 1.036574458 58.28294955
2230 0.0002675385257 0.4721925581 0.9485205639 13.69679
2231 0.01941689445 0.5259695586 1.088071403 80.95140393
2232 0.0334977521 0.4062847644 0.9255912742 63.04799535
2233 0.0001593665511 0.5916957682 1.086235673 34.34011503
2234 0.001061712857 0.4809838442 0.9989569249 74.91984968
2235 0.2692115282 0.5210859768 1.037531276 19.64437383
2236 0.1077303263 0.4604191171 1.060043019 0.2491584094
2237 0.002606172239 0.5375109691 0.9019376559 72.48400028
2238 0.0004109121998 0.4273118924 1.014603976 30.72156564
2239 0.01242315502 0.574707667 0.9719280893 44.50344867
2240 0.01165959255 0.4014064068 1.02099498 33.46496998
2241 0.000437029374 0.5973431017 0.9660145961 63.17930245
2242 0.002776760233 0.4862776343 1.053674814 18.77958702
2243 0.1012768213 0.5150232108 0.9078739475 75.04079853
2244 0.2867540381 0.453569404 0.9927886039 72.35593567
2245 0.0009978374181 0.5451298429 1.044058077 1.127545955
2246 0.0001496034099 0.433746936 0.9317854334 44.38574231
2247 0.03563445377 0.5675034627 1.07973471 31.58959494
2248 0.02065457108 0.4994670015 0.9425475499 5.66422971
2249 0.0002511150978 0.5015774021 1.094402886 67.5698941
2250 0.001573826611 0.4132414537 0.9813428881 25.66187201
2251 0.1769694685 0.5856668402 1.030268802 50.39549017
2252 0.0605661746 0.4453494845 1.070650124 57.16849824
2253 0.004808730703 0.5557423197 0.9162556989 39.39180376
2254 0.0007111679904 0.4669424415 1.003140769 79.82659945
2255 0.007424204333 0.5320130562 0.9583164448 14.24249542
2256 0.007017138183 0.4746718599 1.092222832 47.61501644
2257 0.0004618478148 0.5271538176 0.9442736743 28.5256778
2258 0.003945566877 0.4376703843 1.031543266 70.10150619
2259 0.04385028684 0.5604566356 0.9802736739 3.215301177
2260 0.114815993 0.4209266569 0.9203637248 16.6911833
2261 0.001486087462 0.5809464211 1.066164424 77.29457951
2262 0.000181985913 0.49173148 0.9535011547 36.52823862
2263 0.01696358972 0.5064427439 1.008481705 59.94937981
2264 0.02937728888 0.4258116804 0.9708062455 83.2171876
2265 0.0001088327759 0.5721565543 1.015630355 10.68653002
2266 0.0009462568451 0.4614573216 0.9037422333 55.41779
2267 0.186836665 0.5406247973 1.058136873 41.30916599
2268 0.07360408504 0.4783836136 1.042756852 23.74515828
2269 0.002286933865 0.5195343595 0.9938312002 52.14684691
2270 0.0002850293285 0.4093477655 1.081888146 9.220843613
2271 0.01106774147 0.592683907 0.9300325479 64.17995445
2272 0.009181455886 0.4826173782 0.9852331169 58.75402539
2273 0.0003441639005 0.516081748 1.027909031 35.35365515
2274 0.00220590037 0.4049918829 0.9401938822 78.59105918
2275 0.0804607585 0.5962586366 1.098299218 18.00847698
2276 0.2203630715 0.4348551588 1.000788626 4.594849451
2277 0.0007668591117 0.5638944197 0.9622143015 71.50174689
2278 0.0001144061647 0.4525359612 1.074541878 27.0813202
2279 0.02725238874 0.5487648139 0.9138974521 46.19138927
2280 0.01629440981 0.4182542941 1.051328774 65.47610987
2281 0.000198117038 0.5828374371 0.9117779082 10.53781305
2282 0.001247682281 0.4945258655 1.02488063 50.95181673
2283 0.1403046223 0.5044297053 0.9636502462 22.57089905
2284 0.04662909902 0.4640650693 0.9356695591 39.86513264
2285 0.003702404551 0.536979452 1.077368836 53.99448708
2286 0.0005427207381 0.4481551522 0.9904410401 12.06575404
2287 0.005666053282 0.5507530238 1.047960513 84.61710405
2288 0.008825536453 0.4434347201 0.9014068766 30.33200492
2289 0.0005808358885 0.5584382372 1.062051517 43.1073788
2290 0.005016014087 0.4689304003 0.9747269923 2.361830557
2291 0.05574363113 0.5292439442 1.013301102 73.56940879
2292 0.1503044948 0.4896666383 1.085810417 76.52404577
2293 0.001945303661 0.5121591091 0.9277048191 20.24214438
2294 0.0002366121784 0.4229686223 1.040423019 61.83868435
2295 0.02205416266 0.5751583276 0.9977473678 32.10361893
2296 0.0370157955 0.4570470961 1.035471641 15.47645578
2297 0.0001371224479 0.540870804 0.9779520482 81.03974832
2298 0.001200488406 0.4301959541 1.089882896 38.13453799
2299 0.2370197348 0.5718357915 0.9481837381 55.89045899
2300 0.09653150839 0.4096449837 0.951159694 49.05519632
2301 0.002999122954 0.5883233687 1.012390245 24.30084521
2302 0.0003698155483 0.4781123472 0.9242905747 69.05281709
2303 0.01435912826 0.523969654 1.063841274 7.126462813
2304 0.01404706545 0.4776399398 1.02738394 46.43237986
2305 0.0003617780917 0.5235983487 0.9856845887 27.01121911
2306 0.002971446487 0.4099689875 1.09796944 71.57512594
2307 0.09564061059 0.5887423696 0.9404500416 4.357086155
2308 0.2389929896 0.4298714705 0.9617872441 18.24784126
2309 0.001210481631 0.5714170737 1.001338131 78.51932164
2310 0.000140306425 0.4575192204 0.9136657072 35.42864025
2311 0.03787526502 0.5412425891 1.07489607 58.51787827
2312 0.0218719878 0.4234269988 0.9122297626 84.35828988
2313 0.000234657916 0.5755163888 1.050804066 12.15953547
2314 0.001901166125 0.489352827 0.9639067881 53.90263595
2315 0.1468943279 0.5117510874 1.024551234 40.12592777
2316 0.05698222307 0.4692437379 1.077917958 22.31304244
2317 0.005127472052 0.529652255 0.9352421183 51.04656584
2318 0.0005862436281 0.4429760545 1.048314323 10.44498411
2319 0.008907712959 0.5580806499 0.9902089119 65.73591704
2320 0.005803289268 0.4478322787 1.062381293 32.03286411
2321 0.0005558652955 0.550329835 0.9011507157 62.07903167
2322 0.003729580296 0.464532508 1.013826191 20.00373749
2323 0.04697131369 0.5373526802 0.974275519 76.59677142
2324 0.1394180822 0.494057953 0.9279365655 73.49702766
2325 0.001239797337 0.5040567661 1.085456226 2.600541427
2326 0.000193243936 0.4185768785 0.9981744267 42.87057796
2327 0.01589360034 0.5832610998 1.039873516 30.40634674
2328 0.02742557857 0.4528448038 0.9776955077 7.220897959
2329 0.0001151333313 0.5491747586 1.035801038 68.7946462
2330 0.0007862002643 0.4343979126 0.9477318851 24.56228393
2331 0.225921118 0.5635321707 1.090407605 48.9639986
2332 0.07855832398 0.4054486493 1.012036434 55.98585168
2333 0.002153745656 0.5966211688 0.9513918208 37.87733478
2334 0.0003416548363 0.4823082525 1.063292151 81.30020923
2335 0.009114528448 0.5156722831 0.924718014 15.38427011
2336 0.01113808779 0.4089287728 0.9662467228 31.84646884
2337 0.0002868407078 0.5923598891 1.020641169 44.29001017
2338 0.00234461549 0.4787549345 0.9083013868 1.220040671
2339 0.07546047051 0.5200067572 1.05312569 72.09579395
2340 0.1824192284 0.4610855268 1.044387474 75.29929874
2341 0.0009238833365 0.5401526887 0.9925320635 18.68549133
2342 0.0001080394519 0.426230384 1.08025942 63.27019112
2343 0.02916311825 0.5724810461 0.9313335804 33.20321208
2344 0.01737444404 0.4921395173 1.094048695 14.00344511
2345 0.0001863937403 0.5067565456 0.9427792963 79.89865127
2346 0.001496993931 0.420568604 1.029719298 39.31778111
2347 0.1156587488 0.5804880304 0.981769947 57.40560813
2348 0.04357316866 0.4380279575 0.9159995381 50.1554823
2349 0.003920635984 0.5609153094 1.070979901 25.73295614
2350 0.0004504872806 0.4742635394 0.9578649715 67.49684927
2351 0.006844537228 0.5268404957 1.003665859 5.902327546
2352 0.007362885023 0.4665692288 0.9438462336 59.8543014
2353 0.0007052935224 0.5315456079 1.092771954 36.78575579
2354 0.004699628489 0.4457726816 0.9800415456 77.03508138
2355 0.05919197005 0.556065179 1.031897075 16.78433143
2356 0.1809018 0.4128177768 1.065639716 3.12184907
2357 0.001608796196 0.5853442639 0.9208155792 70.36065981
2358 0.0002534532931 0.499839931 1.00815231 28.26457362
2359 0.02084687012 0.5020453302 0.9537576966 47.70654839
2360 0.03485998663 0.4341091933 1.016179861 64.25135254
2361 0.0001463521176 0.5679606948 0.9703791881 8.981150021
2362 0.000988628259 0.453159475 1.058491066 52.38331321
2363 0.2841078267 0.5448209906 0.9035104884 23.67048223
2364 0.1021198829 0.4866870895 0.994282672 41.37960653
2365 0.002799877445 0.5153323522 1.042231761 55.17712873
2366 0.0004471767429 0.4010438604 0.9302887073 10.92397413
2367 0.01193032812 0.5968863435 1.081558368 83.1434995
2368 0.01269954238 0.4269023322 0.9364617843 8.18900534
2369 0.0004200536556 0.5743984459 1.075035942 64.46569516
2370 0.002630529224 0.4607817447 0.9880867839 22.88873126
2371 0.1087370626 0.5379678309 1.048731376 52.58726212
2372 0.2669808775 0.4806216905 1.052101409 54.9660286
2373 0.001052914626 0.5206288259 0.9094257098 42.1749937
2374 0.0001557454316 0.4066946138 1.02254369 82.94279308
2375 0.03273658696 0.5920045154 0.9644381396 11.7089676
2376 0.01957919892 0.4726161255 1.001567335 36.33539026
2377 0.0002697751311 0.5262920476 0.9598682249 61.05369287
2378 0.001712697453 0.4400923654 1.072198853 16.32356712
2379 0.1699517536 0.5609521588 0.9146792127 78.24487163
2380 0.0630282523 0.4200671759 0.9860193165 69.16321383
2381 0.004416102438 0.5788883979 1.025569968 3.574160095
2382 0.0006622234809 0.4922247143 0.9378456643 46.49870364
2383 0.007834884798 0.5088670138 1.099076263 28.72728342
2384 0.006435576711 0.4970458429 0.9519530939 80.69340023
2385 0.0004799795939 0.501081104 1.010058478 13.79170645
2386 0.004170416797 0.415296437 0.9219374454 58.18996339
2387 0.04089706735 0.5865293134 1.064613312 39.11643617
2388 0.123061104 0.4448570011 1.036244675 25.94664029
2389 0.001405440424 0.5533173464 0.9756002018 49.36267883
2390 0.0001752192655 0.4678011 1.087546308 6.105617983
2391 0.0185079496 0.5340718543 0.9489720313 66.71443951
2392 0.03107103741 0.4020827586 1.08658949 44.7429803
2393 0.0001015642784 0.5999992456 0.9253591534 30.64968102
2394 0.0008670727677 0.4851862792 1.038080405 72.55916286
2395 0.1940077819 0.5127820702 0.9985294916 0.01285407692
2396 0.07083979548 0.4562232591 0.9021941904 19.88552164
2397 0.002494247486 0.5458084835 1.059713616 74.8495711
2398 0.0003055411659 0.4315080842 0.9723799363 34.41364117
2399 0.01046830585 0.5664098188 1.014079261 62.8100647
2400 0.009710845312 0.4581163736 1.06986502 67.92661436
2401 0.0003211790611 0.5431340221 0.91859538 7.338606855
2402 0.002021304723 0.4294929471 1.005489606 48.08561359
2403 0.08354870232 0.5692063028 0.9575404957 24.690346
2404 0.212086772 0.4119104907 0.9417664107 37.75638339
2405 0.0008363731118 0.5893903574 1.096747009 56.85064103
2406 0.0001226396925 0.4754805697 0.9836839594 15.25296554
2407 0.02577642005 0.5232689358 1.029484611 82.17535174
2408 0.01494398046 0.4414003838 0.9920136342 61.53332371
2409 0.0002058954441 0.5575551169 1.046408227 33.15767113
2410 0.001318782018 0.4713798353 0.9341203241 76.06142171
2411 0.1308553569 0.5297119658 1.078944482 21.11818626
2412 0.04997748549 0.4887797033 1.020203754 1.473788917
2413 0.003501480734 0.5101285875 0.9683482038 74.04079012
2414 0.000522541412 0.4234404586 1.056029784 29.28995248
2415 0.00618190365 0.5776039479 0.9071040845 43.40398218
2416 0.008366066421 0.4158056578 1.041972159 13.02496301
2417 0.0006239979251 0.5823685691 0.9961712452 84.23797701
2418 0.00545860774 0.4965595223 1.084237347 41.00170849
2419 0.05353294234 0.5053135527 0.9292570105 53.77196991
2420 0.1564143018 0.4635939125 0.970026269 51.16493321
2421 0.001786465536 0.5345331045 1.017975594 21.44566939
2422 0.000220328626 0.4490412885 0.9060844196 65.86463759
2423 0.02327415314 0.5527843919 1.057353845 9.567257883
2424 0.04031735063 0.4833212316 0.9195898812 27.55432246
2425 0.0001317964586 0.518710438 1.068515747 45.30496919
2426 0.001137265044 0.4039218782 0.9558372192 4.889831264
2427 0.2544789295 0.5939960979 1.007692603 70.45807352
2428 0.08987495303 0.4374876635 1.091431958 79.64348981
2429 0.00316466271 0.5645944584 0.946607681 17.70149542
2430 0.0003849986365 0.4502696078 1.033898635 59.6316882
2431 0.01319144619 0.5476986239 0.9795041621 34.89265264
2432 0.01370599829 0.4211374896 1.088845188 54.33901071
2433 0.0003757845953 0.5799680699 0.9492943007 40.22520266
2434 0.003241862506 0.4911559146 1.037363453 84.97753996
2435 0.0864902907 0.5077888796 0.9761330903 12.41056029
2436 0.2642781349 0.4736910284 0.9231554072 10.14074187
2437 0.001109513557 0.5273640787 1.064854759 65.08428257
2438 0.0001350764883 0.4390159486 0.9529544286 22.17870809
2439 0.03881767547 0.55987859 1.010473827 50.55446073
2440 0.02385629327 0.479357386 0.9727129364 71.19844439
2441 0.0002121590304 0.5193555685 1.015388776 4.275917602
2442 0.001855483527 0.4079604322 0.9027133001 45.87282299
2443 0.1526161311 0.5932793107 1.060818711 26.77830063
2444 0.05484554201 0.4256304106 1.038311123 35.62649927
2445 0.005253680088 0.5731297538 0.9997368189 59.0217048
2446 0.0006484171085 0.4620521523 1.087018619 18.2757924
2447 0.008166841865 0.5392349852 0.9263741722 78.86361879
2448 0.005934530409 0.4541716253 1.022988841 23.9144901
2449 0.0005339779497 0.543760103 0.9654691802 48.65330147
2450 0.003426068764 0.4335612319 1.052366458 6.724851518
2451 0.05205437274 0.5684597371 0.9106673693 68.66682691
2452 0.1258043267 0.400035714 0.9886463294 81.39564411
2453 0.001349632631 0.5979432242 1.049876907 15.82709914
2454 0.0002011644004 0.4872318098 0.9368047027 56.24081848
2455 0.01554208081 0.5148365539 1.076355375 38.49006915
2456 0.02518720908 0.4467146441 0.9388874348 20.50362268
2457 0.0001275636629 0.5551721415 1.099532048 76.80114551
2458 0.0008041872639 0.465944971 0.9872471966 32.38100191
2459 0.2170746912 0.5322185971 1.025821333 62.10052791
2460 0.08175928782 0.4988958688 1.073333653 42.79335138
2461 0.002105560201 0.5029404644 0.9152281228 30.0231495
2462 0.0003083645239 0.4134448972 1.002900547 73.26026917
2463 0.009924592911 0.5846684152 0.9602248266 2.047438831
2464 0.01088927103 0.4898517229 0.9050730709 39.7061768
2465 0.0002985386731 0.5112034572 1.056928482 57.47765654
2466 0.002553064184 0.4223669251 0.9688166037 14.55137016
2467 0.06810954053 0.5765275404 1.017742443 80.14060756
2468 0.2021071151 0.4424800212 1.083120761 67.30802933
2469 0.0008484504043 0.5586254206 0.9287263151 5.386867947
2470 0.0001038061608 0.4703017119 1.040669369 50.11841228
2471 0.02982952638 0.5286432 0.9958450653 25.40037186
2472 0.0189141746 0.4106418369 1.033459493 0.7720341021
2473 0.0001681974483 0.5881184481 0.97847913 72.00555687
2474 0.001463935144 0.4767477095 1.091209538 31.23893289
2475 0.1204033761 0.5245393073 0.945408651 44.0298652
2476 0.04185634481 0.4568431299 0.9553203033 63.56531447
2477 0.004009193857 0.5418697545 1.006589702 33.86655943
2478 0.000499220168 0.4307677047 0.9192529714 75.44267217
2479 0.006287315898 0.5704721082 1.067202323 19.16596335
2480 0.007543914098 0.435431632 0.9833325537 51.87430788
2481 0.0006788287591 0.5625473792 1.02815669 23.47782228
2482 0.004308603582 0.4523241254 0.9412166884 63.91225256
2483 0.06546726563 0.5497441653 1.095611302 8.948021973
2484 0.1635613954 0.481272818 1.005228276 10.98956764
2485 0.001754798873 0.5166587926 0.9563025558 83.53573583
2486 0.0002633348112 0.4059718058 1.069417485 41.62807789
2487 0.0203466455 0.596049281 0.9175619556 55.72111245
2488 0.03195116543 0.4654533098 1.054688084 77.69191303
2489 0.0001618304194 0.5363831442 0.9067389946 17.08339675
2490 0.001013200181 0.4471803773 1.019078777 60.34122769
2491 0.2735103684 0.5509328144 0.9678091161 36.92528921
2492 0.1060771736 0.4176604651 0.9328961629 28.18085161
2493 0.002731989411 0.5842262505 1.078696835 47.25460048
2494 0.0004044043619 0.4947062289 0.9909694791 2.855249201
2495 0.01301639359 0.5034574091 1.045950057 69.75696451
2496 0.0122228535 0.4703125015 0.9969670983 16.21536492
2497 0.0004303887844 0.5307303777 1.039642798 77.80962192
2498 0.002909446272 0.4419057531 0.9269215455 36.0469042
2499 0.09968806039 0.5570010133 1.085027096 60.46928977
2500 0.2912140172 0.4245034041 1.012516678 47.13364909
2501 0.0009519707752 0.5765899215 0.9739425207 29.04564095
2502 0.0001520062592 0.4882779595 1.0612762 69.62565994
2503 0.03401348999 0.5106790686 0.9006316079 3.73039172
2504 0.02164961935 0.4286056643 1.063050705 22.93211432
2505 0.000247268538 0.5701423138 0.9235000532 52.99911489
2506 0.001648834444 0.4587834887 1.011621086 8.412672263
2507 0.1741728376 0.542515835 0.9503904872 65.02670133
2508 0.06150084141 0.4763695676 0.9474096138 82.40898332
2509 0.004587153882 0.5223312067 1.089108724 11.5333301
2510 0.0007224986785 0.4112408975 0.9771626174 54.60471818
2511 0.0070856011 0.5900110256 1.034682257 42.1614821
2512 0.006697943519 0.4033954654 0.9131167952 72.87098442
2513 0.0004692652616 0.5945712389 1.073761268 0.6517212372
2514 0.003764208802 0.4843598986 0.9614306405 44.90564593
2515 0.04453226747 0.5177206989 1.000004917 31.10826685
2516 0.1130149603 0.4507992616 1.097513656 33.98492679
2517 0.001557098076 0.5471202388 0.9394082721 62.69794143
2518 0.0001792208166 0.4364449926 1.027132576 19.2946839
2519 0.01778306134 0.5655882044 0.9844567098 74.56494595
2520 0.0280374189 0.4959140943 1.047168794 58.0207599
2521 0.000110566847 0.5059100587 0.9896493683 38.57876613
2522 0.0009026544432 0.4167191993 1.076598526 80.67335267
2523 0.1897201617 0.5814062933 0.9348992018 13.43431774
2524 0.07244086648 0.449683854 0.9628757464 6.51103612
2525 0.002395930626 0.5521907454 1.024106083 66.76168348
2526 0.0002806629721 0.4626824705 0.9109881019 26.51418179
2527 0.01160094726 0.5354932837 1.050539016 49.58242468
2528 0.009328317901 0.4391015271 1.00925521 76.00900083
2529 0.0003284469006 0.5619917285 0.9542746114 20.71796529
2530 0.002240081208 0.4731915075 1.06695314 61.31877693
2531 0.07674852176 0.5257655906 0.921152488 32.58495082
2532 0.2308797875 0.4932176523 0.9810665796 29.81204937
2533 0.0007546937143 0.5078253476 1.03233622 43.58873856
2534 0.0001199252042 0.4194889313 0.9450452654 1.846732413
2535 0.02683327342 0.5794177145 1.092994375 74.04526264
2536 0.01655711787 0.4598183747 0.9308194038 48.20293594
2537 0.0001890935821 0.5388822818 1.082674954 25.11388157
2538 0.001267164044 0.4274990739 0.994608853 68.20606261
2539 0.1338473288 0.5737529669 1.043534552 7.934641764
2540 0.0488601855 0.4076539798 1.058916428 14.62965317
2541 0.00364410455 0.5910940714 0.9045218352 81.84795514
2542 0.0005689731212 0.4800281897 1.016413009 37.2822244
2543 0.00557962319 0.521271061 0.9715888515 56.70352828
2544 0.008689815515 0.4846326081 1.080507064 5.070666568
2545 0.0006088551951 0.5132868223 0.9325577397 70.98670574
2546 0.004936445704 0.4030998796 1.044845642 27.56265589
2547 0.05840391892 0.5989333874 0.9935762167 45.67147805
2548 0.1433700153 0.4320592772 0.9086664777 59.23538894
2549 0.001975444854 0.5659075478 1.054467392 34.8336958
2550 0.0002258069525 0.4552078532 0.9667858116 79.06690923
2551 0.02240690605 0.5468726236 1.021766148 17.49338264
2552 0.03645111666 0.4146786757 0.9591029132 40.6781728
2553 0.0001437554286 0.587195806 1.00392719 53.14222289
2554 0.0011815839 0.4979805699 0.9170329643 12.87392919
2555 0.2483608066 0.5001953021 1.071427437 83.77035337
2556 0.09208872486 0.4684224868 1.031047218 66.28431288
2557 0.003045955617 0.5334017392 0.9821213515 9.691014234
2558 0.0003529715181 0.4439178858 1.095184401 51.76488982
2559 0.01459064676 0.5542075338 0.9433290174 21.71858167
2560 0.01446286959 0.4682827476 1.084384178 42.26908536
2561 0.0003498803907 0.5329692693 0.9270600652 55.03924957
2562 0.003060876484 0.4443520719 1.039381537 11.63583023
2563 0.0925398264 0.5543486085 0.9974869 82.84861783
2564 0.2461857646 0.4142444929 0.9000743298 64.55845436
2565 0.001171236109 0.5870547339 1.061499978 8.26096477
2566 0.0001444596438 0.4981203057 0.9737909326 52.51537615
2567 0.03662967878 0.5006277693 1.013146534 22.7958986
2568 0.02260487023 0.4327984469 0.9505167998 3.500782074
2569 0.0002278019417 0.566158675 1.01096596 69.06927923
2570 0.00196581491 0.454958443 0.9240320619 28.82129149
2571 0.1426711161 0.5461347887 1.062801651 46.57200819
2572 0.05891990832 0.484882015 1.034918243 60.98156624
2573 0.004980058273 0.5140246546 0.9766175464 36.24279825
2574 0.0006058872061 0.4023607133 1.089726372 78.33754723
2575 0.008647455493 0.5986822627 0.9472458187 16.39561015
2576 0.005617925792 0.4072212741 1.000656708 49.43589504
2577 0.0005728789847 0.590954574 0.9613013685 26.0407367
2578 0.003605137736 0.4801694049 1.074013466 66.62026964
2579 0.04833771668 0.5217051007 0.9125875551 6.032475233
2580 0.1347661706 0.459677157 0.9849988274 13.86367127
2581 0.001275862973 0.5384482387 1.02689325 80.78615405
2582 0.0001870715612 0.4279317822 0.9395748299 39.02359876
2583 0.01638006833 0.5738924677 1.096899157 58.11808217
2584 0.02665032297 0.4934685385 0.9347577227 74.75564188
2585 0.0001191075453 0.5085647523 1.07723811 19.81213823
2586 0.0007628510552 0.418751242 0.9891323352 62.88336451
2587 0.2333753302 0.5791681645 1.047433198 34.50765398
2588 0.07622525603 0.4398392189 1.050311897 30.55708426
2589 0.002224808434 0.5622412818 0.9115424266 44.67085843
2590 0.0003319969811 0.4729406187 1.023479377 0.08490248583
2591 0.009429145073 0.5250261825 0.9630300971 72.65183308
2592 0.01147689705 0.4495427845 0.9216967037 56.92276701
2593 0.0002776618036 0.551756563 1.066716293 37.84897603
2594 0.00241237804 0.4631149352 0.9544375451 82.08267551
2595 0.07293815558 0.5356330192 1.008636706 15.18092315
2596 0.1876914406 0.4954816263 1.093648645 7.411984242
2597 0.0008930021261 0.5057703206 0.9449180914 68.0205496
2598 0.0001113258718 0.4168602722 1.032584412 24.5963373
2599 0.0282298924 0.5818404783 0.9805337155 48.01230967
2600 0.01797527507 0.4515370943 1.043309913 73.94803029
2601 0.0001811579857 0.5473696483 0.9951652758 1.40183012
2602 0.001546481712 0.4361938676 1.082044243 43.47586751
2603 0.1122444159 0.5648490354 0.9309701305 29.38278577
2604 0.04501360291 0.4036465937 0.9714494705 33.06357883
2605 0.003804895079 0.5953104105 1.017055072 61.46010338
2606 0.0004660658458 0.4836220626 0.9040011782 21.19132299
2607 0.006652277238 0.5174712868 1.059176827 76.1555976
2608 0.007120310508 0.4759355256 0.9930225626 21.53826678
2609 0.0007260378769 0.5221899908 1.045073426 51.23705444
2610 0.004546982014 0.4113803972 0.9324040536 9.495210107
2611 0.06096225138 0.590443732 1.08113444 65.77196674
2612 0.1750260586 0.4284661673 1.021127235 84.33190687
2613 0.001656911546 0.5697096108 0.9669279553 13.09834579
2614 0.0002451030617 0.4592175281 1.054203651 53.69867073
2615 0.02146002151 0.5426570475 0.9091841813 40.90769505
2616 0.03384768025 0.4247529592 1.071667428 17.62953124
2617 0.0001512652601 0.5773276145 0.9164915172 79.55073536
2618 0.0009603814012 0.4875385495 1.004542359 34.98549069
2619 0.2937868734 0.5104281787 0.95893702 59.70356879
2620 0.09920211057 0.4710519088 0.9434589541 45.23175361
2621 0.002895263669 0.5309812643 1.094533282 27.46022542
2622 0.0004341912013 0.4416562006 0.9826512622 70.55224402
2623 0.01233084012 0.5562633237 1.030795685 4.96297338
2624 0.01313139098 0.4175069934 0.9762875393 78.42656941
2625 0.0004079772106 0.5837800473 1.03673684 18.17587486
2626 0.002718671851 0.4951510958 0.9498487178 58.58975601
2627 0.1055600787 0.5036091654 1.088618167 35.52148114
2628 0.275926814 0.4650084455 1.01073833 26.91712428
2629 0.001022151766 0.5362313913 0.952437488 46.35916206
2630 0.0001610415296 0.4473338464 1.065494434 4.430225422
2631 0.03179540915 0.5513790142 0.9230140265 71.6692993
2632 0.02016845853 0.4819982544 1.060204305 51.11868929
2633 0.0002610286331 0.5168961873 0.9028799562 22.40563761
2634 0.00176339506 0.405733077 1.015149548 65.64324334
2635 0.1643626341 0.5953221269 0.9732551465 10.37293918
2636 0.06489393988 0.4356703581 0.9258450245 12.23292045
2637 0.00427087111 0.5632745299 1.087270915 84.45221751
2638 0.0006821540381 0.4515986916 0.9996076452 40.03191147
2639 0.00758086859 0.549506774 1.038963005 53.82933963
2640 0.006244449258 0.4563966917 0.9105036726 2.52857978
2641 0.0004958165219 0.5417165238 1.052984199 73.40427068
2642 0.004052528109 0.4309196007 0.9649242016 30.49918226
2643 0.04230875704 0.5709168294 1.023224925 42.94246108
2644 0.1195824569 0.4104899377 1.07610642 62.00580849
2645 0.001453953969 0.5876737243 0.9373368038 31.93877467
2646 0.0001700154677 0.4771941511 1.049221874 76.69094952
2647 0.01911861431 0.5246925406 0.9887727404 20.07687201
2648 0.03003430248 0.4427171741 1.026451281 37.96992457
2649 0.0001045187745 0.5593510928 0.9870957069 56.05798052
2650 0.0008393777049 0.4695747042 1.099755925 15.31222994
2651 0.1999459374 0.5284043308 0.9383302491 81.20753077
2652 0.06857709612 0.4905787339 0.9607447207 68.88857858
2653 0.002570590278 0.511442329 1.002639385 7.294278196
2654 0.0002953463572 0.4221297689 0.9153667409 48.89069689
2655 0.01077283085 0.5758018656 1.072690827 24.46827301
2656 0.01003186505 0.4987441178 1.017491008 18.61210571
2657 0.0003116975402 0.5024956012 0.9693466067 75.20537174
2658 0.002091204586 0.4138910951 1.056277454 33.29722774
2659 0.08120185906 0.5848218832 0.9052031059 63.34348808
2660 0.2194210168 0.4462684436 0.9956792705 44.21788608
2661 0.0008128795711 0.5550186701 1.04128463 31.7538743
2662 0.0001266939244 0.4660967246 0.9281849604 72.18846702
2663 0.02501548157 0.5326634636 1.08336085 1.29208623
2664 0.01537588533 0.4007628659 0.945926447 25.82705033
2665 0.0001990133035 0.5981819522 1.090945896 50.22870073
2666 0.001358897696 0.4869944174 0.978621372 5.829187646
2667 0.1266679545 0.5141111182 1.032820673 67.40267655
2668 0.05149774803 0.4544090204 1.067829791 79.99140286
2669 0.003389433431 0.544485542 0.9190993836 14.07541214
2670 0.0005376435798 0.4328340774 1.006817584 57.33372977
2671 0.005975269352 0.5682210058 0.9547667416 39.22494086
2672 0.008127031168 0.4251856871 1.095871799 70.26672806
2673 0.0006452562668 0.5729778571 0.9406961238 3.0484682
2674 0.005300095363 0.4622053852 1.028798846 47.77985073
2675 0.05533009371 0.5396814242 0.983193271 28.3585839
2676 0.151872159 0.4792041564 0.9177127806 36.69316663
2677 0.001846438374 0.5189091321 1.068786867 59.78217192
2678 0.0002140334411 0.4084051523 0.956859071 16.85637224
2679 0.02406706272 0.5934312047 1.005003735 77.1277592
2680 0.03900783058 0.4739299027 0.9672763444 55.25035254
2681 0.000135738188 0.5280910902 1.019327068 41.47369534
2682 0.001099796926 0.4382902712 0.906611919 83.04932203
2683 0.2619636955 0.5596414333 1.055342446 10.85083898
2684 0.08691396801 0.4218631636 1.045331645 9.053112301
2685 0.00325774304 0.5802052239 0.9911325112 64.34410889
2686 0.0003724936837 0.4909170436 1.078460087 23.57764735
2687 0.01358596841 0.5070618708 0.9334404711 52.31142946
2688 0.0132560652 0.4367484938 1.04899559 28.95170635
2689 0.0003868845845 0.5643433312 0.9875699416 47.06027107
2690 0.003136948361 0.4505190181 1.075675716 3.803696278
2691 0.08908787571 0.5484364588 0.9363201145 69.71966801
2692 0.2557255386 0.4830718247 0.9645926811 77.71702992
2693 0.001142836168 0.5179726057 1.021916794 16.1432383
2694 0.0001306422432 0.4046610445 0.9099798437 60.54133279
2695 0.03996426783 0.5942472225 1.051874481 36.1395798
2696 0.02316069646 0.4637336517 0.9141501633 11.60655106
2697 0.000219254563 0.5349655744 1.07245086 82.50307498
2698 0.001802248838 0.4486071024 0.9597387621 42.06730685
2699 0.1577962163 0.5526433172 1.002219316 54.53158082
2700 0.05327198666 0.4162398405 1.098461573 53.07107432
2701 0.005431998642 0.5825096412 0.9380124127 23.02487352
2702 0.0006295108295 0.4964197865 1.025330833 64.93386867
2703 0.008439979297 0.5048810855 0.9865612434 8.340786295
2704 0.006115799687 0.4885288171 1.064364067 62.62455802
2705 0.0005169538188 0.5093891827 0.9224696448 33.89099758
2706 0.003525517556 0.4241781479 1.009403543 74.65895876
2707 0.05032056739 0.5778534979 0.9520792158 19.36798371
2708 0.1294560867 0.4406626919 0.948808427 0.5795993656
2709 0.00130467998 0.5573055636 1.088163766 72.77838766
2710 0.0002073088915 0.4716307241 0.97505494 31.20093707
2711 0.01504656864 0.5304513739 1.036480851 44.97769434
2712 0.02605503326 0.4123431964 0.999049484 66.85577989
2713 0.0001239652816 0.5895298548 1.037818954 6.584252333
2714 0.000830670658 0.4753393546 0.9254974823 49.50928193
2715 0.210640755 0.5228348961 1.085946762 26.42001192
2716 0.08445175681 0.4582575914 1.014708926 38.67151995
2717 0.002043152377 0.5435680652 0.972228539 58.09272471
2718 0.0003189892765 0.4290602388 1.059937585 13.36243652
2719 0.009644637489 0.569066802 0.9016367216 80.58051526
2720 0.01054016824 0.4554854264 0.9573744118 43.51677976
2721 0.0003076386233 0.545559074 1.006104966 29.71928954
2722 0.002467576147 0.4317592092 0.9180541236 74.13809593
2723 0.0700822977 0.5671489878 1.07010482 1.918617748
2724 0.1953396219 0.4018316302 1.029233269 20.64474497
2725 0.0008730250915 0.5992600741 0.9842136793 75.91490854
2726 0.0001004782253 0.4859241152 1.096095699 32.67912671
2727 0.0307387877 0.5130314823 0.9418965381 61.39191367
2728 0.01838176103 0.4449980706 1.079572049 81.94054778
2729 0.0001740246128 0.5537515288 0.9339664472 14.70177915
2730 0.001420631605 0.4673686353 1.046635819 56.63148589
2731 0.124391248 0.5339321189 0.9914601708 37.18954817
2732 0.04061823297 0.497478311 0.9076215973 25.2078168
2733 0.004141983204 0.5012208421 1.055766234 48.27631332
2734 0.0004851675586 0.4151553642 0.9684905382 7.861337839
2735 0.006505136861 0.5860951284 1.019564651 68.11205391
2736 0.007766271252 0.4198176207 0.9294075465 34.74094135
2737 0.0006564240779 0.5781507049 1.083606826 59.16342476
2738 0.004437734952 0.4929641243 0.9967278587 17.56526323
2739 0.06333700145 0.5091179037 1.041747329 79.15974727
2740 0.1684633909 0.4718767181 1.057614435 70.8926087
2741 0.001697698351 0.5260411611 0.9055635719 4.997450989
2742 0.0002710966714 0.440341918 1.018617466 45.74462017
2743 0.01967511161 0.5616898485 0.9698870787 27.6568264
2744 0.03302581249 0.4810557324 1.00707429 9.763135472
2745 0.0001571214367 0.5207700418 0.9559999622 66.37691027
2746 0.001047781884 0.4065551141 1.06827871 21.62591082
2747 0.265679393 0.591571809 0.9201342877 51.69284204
2748 0.1096977341 0.4270418292 0.9789711073 53.21560566
2749 0.002653769534 0.574831149 1.034147018 40.77210265
2750 0.0004180060307 0.4603477053 0.9464806978 83.67633992
2751 0.01263763586 0.5378266184 1.092086037 12.80063002
2752 0.01187217129 0.4859616531 0.9398926651 65.17687774
2753 0.0004449969018 0.5150949575 1.098193507 10.21286533
2754 0.00282461392 0.4012825891 0.9855332898 50.48241581
2755 0.1030220928 0.5976134976 1.028013697 22.08603438
2756 0.2827228514 0.4338704672 1.074253435 40.3191303
2757 0.0009838089006 0.567233544 0.9138041345 54.4123957
2758 0.000147645133 0.4538849087 1.001076778 12.33726396
2759 0.03516797225 0.5450583819 0.9623073289 84.88352366
2760 0.02094899275 0.4129712485 1.024787509 58.9497384
2761 0.000254694878 0.5857904671 0.9633616187 35.53374704
2762 0.001594707019 0.4993950641 1.051421617 78.95645968
2763 0.1793175416 0.501893574 0.9120662566 18.34767014
2764 0.05948192685 0.4670140931 0.9903351322 4.202699806
2765 0.004722649871 0.5316973608 1.047659481 71.10434957
2766 0.0006991169347 0.4456192125 0.9357744101 26.87247399
2767 0.007298404987 0.5556189792 1.077668812 45.94596226
2768 0.006918517705 0.4377908045 0.9748175383 15.89922798
2769 0.0004553564713 0.5601896372 1.013587154 81.4882339
2770 0.003893905379 0.4749905471 0.9013175625 38.3973907
2771 0.04327608873 0.5270793648 1.061766696 56.1687783
2772 0.1169088822 0.4914125063 1.040525589 48.7266817
2773 0.001513174699 0.5065176738 0.9980450623 24.00842248
2774 0.0001851228995 0.4208057603 1.085708332 68.572816
2775 0.0172559838 0.5812137052 0.9274076086 6.65154981
2776 0.02885127035 0.4615319651 1.090180775 29.93039252
2777 0.0001068841581 0.5403059194 0.9482861115 42.72138974
2778 0.0009302256563 0.4260784881 1.035174234 2.119321949
2779 0.1836715144 0.5720363248 0.9778501475 73.35310468
2780 0.07465356334 0.4090806721 0.9245764425 76.70705607
2781 0.002319544187 0.592804613 1.063932017 20.4303995
2782 0.0002888097916 0.4783084929 0.9508750709 62.17366242
2783 0.01121454808 0.5198535239 1.012300746 32.47518001
2784 0.009052386268 0.4047214974 1.053779862 5.460086376
2785 0.0003393254488 0.5963824408 0.9081745019 67.40212352
2786 0.002177024824 0.482545645 1.02088965 25.30619914
2787 0.07940743887 0.5163977187 0.9657137604 50.04527238
2788 0.2243807778 0.4526074087 0.9318780793 57.54962357
2789 0.0007808398927 0.5484493196 1.080022481 39.7989284
2790 0.0001163777856 0.4351250671 0.9926949048 80.0477673
2791 0.02772201726 0.563770902 1.043769253 14.47949179
2792 0.01600270751 0.494209704 0.9816308551 33.77263242
2793 0.0001945705323 0.5045016292 1.030361263 63.49192885
2794 0.0012265399 0.4181306805 0.9422585409 19.23926031
2795 0.1379272486 0.5831076318 1.094309383 75.53668784
2796 0.04729375903 0.4482784793 1.003441127 71.91296233
2797 0.003755182967 0.5504833063 0.9584216774 0.6999100139
2798 0.0005499213663 0.4643807543 1.070349473 44.10191076
2799 0.005741233882 0.5369078137 0.9161501724 31.33160596
}
sw sweep paramset=pts {
  tr tran stop=2n maxstep=1p errpreset=conservative outputstart=1.99n
}
