// Design: SAL45/STRONGARM_TB
simulator lang=spectre
global 0
parameters tper=2e-09 tpw=1.2e-09 trf=2e-11 tdel=2e-10 cl=5e-15 dvin=0.001 vcm=0.5 vdd=1.0
include "/CMC/kits/cadence/GPDK045/gpdk045_v_6_0/models/spectre/gpdk045.scs" section=tt

// SAL45/INV45/schematic
subckt INV45 IN OUT VDD VSS
    MP (OUT IN VDD VDD) g45p1lvt w=(700n) l=45n nf=1 m=(1)
    MN (OUT IN VSS VSS) g45n1lvt w=(250n) l=45n nf=1 m=(1)
ends INV45

// SAL45/STRONGARM/schematic
subckt STRONGARM CLK INN INP OUTN OUTP VDD VSS
    M4 (Y X Q VSS) g45n1lvt w=(2u) l=45n nf=2 m=(1)
    M3 (X Y P VSS) g45n1lvt w=(2u) l=45n nf=2 m=(1)
    M0 (TAIL CLK VSS VSS) g45n1lvt w=(8u) l=45n nf=4 m=(1)
    M2 (Q INN TAIL VSS) g45n1lvt w=(12u) l=45n nf=4 m=(1)
    M1 (P INP TAIL VSS) g45n1lvt w=(12u) l=45n nf=4 m=(1)
    S4 (Q CLK VDD VDD) g45p1lvt w=(1u) l=45n nf=1 m=(1)
    S3 (P CLK VDD VDD) g45p1lvt w=(1u) l=45n nf=1 m=(1)
    S2 (Y CLK VDD VDD) g45p1lvt w=(1u) l=45n nf=1 m=(1)
    S1 (X CLK VDD VDD) g45p1lvt w=(1u) l=45n nf=1 m=(1)
    M6 (Y X VDD VDD) g45p1lvt w=(2u) l=45n nf=2 m=(1)
    M5 (X Y VDD VDD) g45p1lvt w=(2u) l=45n nf=2 m=(1)
    I_INVN (Y OUTN VDD VSS) INV45
    I_INVP (X OUTP VDD VSS) INV45
ends STRONGARM

// SAL45/STRONGARM_TB/schematic
I_SA (clk inn inp outn outp vdd 0) STRONGARM
VINN (inn 0) vsource dc=vcm-dvin/2 type=dc
VINP (inp 0) vsource dc=vcm+dvin/2 type=dc
V0 (vsup 0) vsource dc=vdd type=dc
VCLK (clk 0) vsource type=pulse val0=0 val1=vdd period=tper delay=tdel rise=trf fall=trf width=tpw
CLN (outn 0) capacitor c=cl
CLP (outp 0) capacitor c=cl
parameters pid=0
ahdl_include "/home/jesselevine/Desktop/StrongArm45/latch/veriloga/sa_meter.va"
// ---- experiment ds_slices
MTR (clk outp outn vsup vdd) sa_meter vdd=vdd pid=pid dvin=dvin vcm=vcm file="raw/ds_slices/meter.txt"
simOpts options reltol=1e-6 vabstol=1e-12 iabstol=1e-13 temp=27 tnom=27 save=none
pts paramset {
pid dvin vcm vdd temp
0 1e-06 0.5 1 27
1 1.467799268e-06 0.5 1 27
2 2.15443469e-06 0.5 1 27
3 3.16227766e-06 0.5 1 27
4 4.641588834e-06 0.5 1 27
5 6.812920691e-06 0.5 1 27
6 1e-05 0.5 1 27
7 1.467799268e-05 0.5 1 27
8 2.15443469e-05 0.5 1 27
9 3.16227766e-05 0.5 1 27
10 4.641588834e-05 0.5 1 27
11 6.812920691e-05 0.5 1 27
12 0.0001 0.5 1 27
13 0.0001467799268 0.5 1 27
14 0.000215443469 0.5 1 27
15 0.000316227766 0.5 1 27
16 0.0004641588834 0.5 1 27
17 0.0006812920691 0.5 1 27
18 0.001 0.5 1 27
19 0.001467799268 0.5 1 27
20 0.00215443469 0.5 1 27
21 0.00316227766 0.5 1 27
22 0.004641588834 0.5 1 27
23 0.006812920691 0.5 1 27
24 0.01 0.5 1 27
25 0.01467799268 0.5 1 27
26 0.0215443469 0.5 1 27
27 0.0316227766 0.5 1 27
28 0.04641588834 0.5 1 27
29 0.06812920691 0.5 1 27
30 0.1 0.5 1 27
31 0.1467799268 0.5 1 27
32 0.215443469 0.5 1 27
33 0.3 0.5 1 27
34 1e-06 0.4 1 27
35 1.467799268e-06 0.4 1 27
36 2.15443469e-06 0.4 1 27
37 3.16227766e-06 0.4 1 27
38 4.641588834e-06 0.4 1 27
39 6.812920691e-06 0.4 1 27
40 1e-05 0.4 1 27
41 1.467799268e-05 0.4 1 27
42 2.15443469e-05 0.4 1 27
43 3.16227766e-05 0.4 1 27
44 4.641588834e-05 0.4 1 27
45 6.812920691e-05 0.4 1 27
46 0.0001 0.4 1 27
47 0.0001467799268 0.4 1 27
48 0.000215443469 0.4 1 27
49 0.000316227766 0.4 1 27
50 0.0004641588834 0.4 1 27
51 0.0006812920691 0.4 1 27
52 0.001 0.4 1 27
53 0.001467799268 0.4 1 27
54 0.00215443469 0.4 1 27
55 0.00316227766 0.4 1 27
56 0.004641588834 0.4 1 27
57 0.006812920691 0.4 1 27
58 0.01 0.4 1 27
59 0.01467799268 0.4 1 27
60 0.0215443469 0.4 1 27
61 0.0316227766 0.4 1 27
62 0.04641588834 0.4 1 27
63 0.06812920691 0.4 1 27
64 0.1 0.4 1 27
65 0.1467799268 0.4 1 27
66 0.215443469 0.4 1 27
67 0.3 0.4 1 27
68 1e-06 0.6 1 27
69 1.467799268e-06 0.6 1 27
70 2.15443469e-06 0.6 1 27
71 3.16227766e-06 0.6 1 27
72 4.641588834e-06 0.6 1 27
73 6.812920691e-06 0.6 1 27
74 1e-05 0.6 1 27
75 1.467799268e-05 0.6 1 27
76 2.15443469e-05 0.6 1 27
77 3.16227766e-05 0.6 1 27
78 4.641588834e-05 0.6 1 27
79 6.812920691e-05 0.6 1 27
80 0.0001 0.6 1 27
81 0.0001467799268 0.6 1 27
82 0.000215443469 0.6 1 27
83 0.000316227766 0.6 1 27
84 0.0004641588834 0.6 1 27
85 0.0006812920691 0.6 1 27
86 0.001 0.6 1 27
87 0.001467799268 0.6 1 27
88 0.00215443469 0.6 1 27
89 0.00316227766 0.6 1 27
90 0.004641588834 0.6 1 27
91 0.006812920691 0.6 1 27
92 0.01 0.6 1 27
93 0.01467799268 0.6 1 27
94 0.0215443469 0.6 1 27
95 0.0316227766 0.6 1 27
96 0.04641588834 0.6 1 27
97 0.06812920691 0.6 1 27
98 0.1 0.6 1 27
99 0.1467799268 0.6 1 27
100 0.215443469 0.6 1 27
101 0.3 0.6 1 27
102 1e-06 0.5 0.9 27
103 1.467799268e-06 0.5 0.9 27
104 2.15443469e-06 0.5 0.9 27
105 3.16227766e-06 0.5 0.9 27
106 4.641588834e-06 0.5 0.9 27
107 6.812920691e-06 0.5 0.9 27
108 1e-05 0.5 0.9 27
109 1.467799268e-05 0.5 0.9 27
110 2.15443469e-05 0.5 0.9 27
111 3.16227766e-05 0.5 0.9 27
112 4.641588834e-05 0.5 0.9 27
113 6.812920691e-05 0.5 0.9 27
114 0.0001 0.5 0.9 27
115 0.0001467799268 0.5 0.9 27
116 0.000215443469 0.5 0.9 27
117 0.000316227766 0.5 0.9 27
118 0.0004641588834 0.5 0.9 27
119 0.0006812920691 0.5 0.9 27
120 0.001 0.5 0.9 27
121 0.001467799268 0.5 0.9 27
122 0.00215443469 0.5 0.9 27
123 0.00316227766 0.5 0.9 27
124 0.004641588834 0.5 0.9 27
125 0.006812920691 0.5 0.9 27
126 0.01 0.5 0.9 27
127 0.01467799268 0.5 0.9 27
128 0.0215443469 0.5 0.9 27
129 0.0316227766 0.5 0.9 27
130 0.04641588834 0.5 0.9 27
131 0.06812920691 0.5 0.9 27
132 0.1 0.5 0.9 27
133 0.1467799268 0.5 0.9 27
134 0.215443469 0.5 0.9 27
135 0.3 0.5 0.9 27
136 1e-06 0.5 1.1 27
137 1.467799268e-06 0.5 1.1 27
138 2.15443469e-06 0.5 1.1 27
139 3.16227766e-06 0.5 1.1 27
140 4.641588834e-06 0.5 1.1 27
141 6.812920691e-06 0.5 1.1 27
142 1e-05 0.5 1.1 27
143 1.467799268e-05 0.5 1.1 27
144 2.15443469e-05 0.5 1.1 27
145 3.16227766e-05 0.5 1.1 27
146 4.641588834e-05 0.5 1.1 27
147 6.812920691e-05 0.5 1.1 27
148 0.0001 0.5 1.1 27
149 0.0001467799268 0.5 1.1 27
150 0.000215443469 0.5 1.1 27
151 0.000316227766 0.5 1.1 27
152 0.0004641588834 0.5 1.1 27
153 0.0006812920691 0.5 1.1 27
154 0.001 0.5 1.1 27
155 0.001467799268 0.5 1.1 27
156 0.00215443469 0.5 1.1 27
157 0.00316227766 0.5 1.1 27
158 0.004641588834 0.5 1.1 27
159 0.006812920691 0.5 1.1 27
160 0.01 0.5 1.1 27
161 0.01467799268 0.5 1.1 27
162 0.0215443469 0.5 1.1 27
163 0.0316227766 0.5 1.1 27
164 0.04641588834 0.5 1.1 27
165 0.06812920691 0.5 1.1 27
166 0.1 0.5 1.1 27
167 0.1467799268 0.5 1.1 27
168 0.215443469 0.5 1.1 27
169 0.3 0.5 1.1 27
170 1e-06 0.5 1 0
171 1.467799268e-06 0.5 1 0
172 2.15443469e-06 0.5 1 0
173 3.16227766e-06 0.5 1 0
174 4.641588834e-06 0.5 1 0
175 6.812920691e-06 0.5 1 0
176 1e-05 0.5 1 0
177 1.467799268e-05 0.5 1 0
178 2.15443469e-05 0.5 1 0
179 3.16227766e-05 0.5 1 0
180 4.641588834e-05 0.5 1 0
181 6.812920691e-05 0.5 1 0
182 0.0001 0.5 1 0
183 0.0001467799268 0.5 1 0
184 0.000215443469 0.5 1 0
185 0.000316227766 0.5 1 0
186 0.0004641588834 0.5 1 0
187 0.0006812920691 0.5 1 0
188 0.001 0.5 1 0
189 0.001467799268 0.5 1 0
190 0.00215443469 0.5 1 0
191 0.00316227766 0.5 1 0
192 0.004641588834 0.5 1 0
193 0.006812920691 0.5 1 0
194 0.01 0.5 1 0
195 0.01467799268 0.5 1 0
196 0.0215443469 0.5 1 0
197 0.0316227766 0.5 1 0
198 0.04641588834 0.5 1 0
199 0.06812920691 0.5 1 0
200 0.1 0.5 1 0
201 0.1467799268 0.5 1 0
202 0.215443469 0.5 1 0
203 0.3 0.5 1 0
204 1e-06 0.5 1 85
205 1.467799268e-06 0.5 1 85
206 2.15443469e-06 0.5 1 85
207 3.16227766e-06 0.5 1 85
208 4.641588834e-06 0.5 1 85
209 6.812920691e-06 0.5 1 85
210 1e-05 0.5 1 85
211 1.467799268e-05 0.5 1 85
212 2.15443469e-05 0.5 1 85
213 3.16227766e-05 0.5 1 85
214 4.641588834e-05 0.5 1 85
215 6.812920691e-05 0.5 1 85
216 0.0001 0.5 1 85
217 0.0001467799268 0.5 1 85
218 0.000215443469 0.5 1 85
219 0.000316227766 0.5 1 85
220 0.0004641588834 0.5 1 85
221 0.0006812920691 0.5 1 85
222 0.001 0.5 1 85
223 0.001467799268 0.5 1 85
224 0.00215443469 0.5 1 85
225 0.00316227766 0.5 1 85
226 0.004641588834 0.5 1 85
227 0.006812920691 0.5 1 85
228 0.01 0.5 1 85
229 0.01467799268 0.5 1 85
230 0.0215443469 0.5 1 85
231 0.0316227766 0.5 1 85
232 0.04641588834 0.5 1 85
233 0.06812920691 0.5 1 85
234 0.1 0.5 1 85
235 0.1467799268 0.5 1 85
236 0.215443469 0.5 1 85
237 0.3 0.5 1 85
238 1e-06 0.4 0.9 85
239 1.467799268e-06 0.4 0.9 85
240 2.15443469e-06 0.4 0.9 85
241 3.16227766e-06 0.4 0.9 85
242 4.641588834e-06 0.4 0.9 85
243 6.812920691e-06 0.4 0.9 85
244 1e-05 0.4 0.9 85
245 1.467799268e-05 0.4 0.9 85
246 2.15443469e-05 0.4 0.9 85
247 3.16227766e-05 0.4 0.9 85
248 4.641588834e-05 0.4 0.9 85
249 6.812920691e-05 0.4 0.9 85
250 0.0001 0.4 0.9 85
251 0.0001467799268 0.4 0.9 85
252 0.000215443469 0.4 0.9 85
253 0.000316227766 0.4 0.9 85
254 0.0004641588834 0.4 0.9 85
255 0.0006812920691 0.4 0.9 85
256 0.001 0.4 0.9 85
257 0.001467799268 0.4 0.9 85
258 0.00215443469 0.4 0.9 85
259 0.00316227766 0.4 0.9 85
260 0.004641588834 0.4 0.9 85
261 0.006812920691 0.4 0.9 85
262 0.01 0.4 0.9 85
263 0.01467799268 0.4 0.9 85
264 0.0215443469 0.4 0.9 85
265 0.0316227766 0.4 0.9 85
266 0.04641588834 0.4 0.9 85
267 0.06812920691 0.4 0.9 85
268 0.1 0.4 0.9 85
269 0.1467799268 0.4 0.9 85
270 0.215443469 0.4 0.9 85
271 0.3 0.4 0.9 85
272 1e-06 0.6 1.1 0
273 1.467799268e-06 0.6 1.1 0
274 2.15443469e-06 0.6 1.1 0
275 3.16227766e-06 0.6 1.1 0
276 4.641588834e-06 0.6 1.1 0
277 6.812920691e-06 0.6 1.1 0
278 1e-05 0.6 1.1 0
279 1.467799268e-05 0.6 1.1 0
280 2.15443469e-05 0.6 1.1 0
281 3.16227766e-05 0.6 1.1 0
282 4.641588834e-05 0.6 1.1 0
283 6.812920691e-05 0.6 1.1 0
284 0.0001 0.6 1.1 0
285 0.0001467799268 0.6 1.1 0
286 0.000215443469 0.6 1.1 0
287 0.000316227766 0.6 1.1 0
288 0.0004641588834 0.6 1.1 0
289 0.0006812920691 0.6 1.1 0
290 0.001 0.6 1.1 0
291 0.001467799268 0.6 1.1 0
292 0.00215443469 0.6 1.1 0
293 0.00316227766 0.6 1.1 0
294 0.004641588834 0.6 1.1 0
295 0.006812920691 0.6 1.1 0
296 0.01 0.6 1.1 0
297 0.01467799268 0.6 1.1 0
298 0.0215443469 0.6 1.1 0
299 0.0316227766 0.6 1.1 0
300 0.04641588834 0.6 1.1 0
301 0.06812920691 0.6 1.1 0
302 0.1 0.6 1.1 0
303 0.1467799268 0.6 1.1 0
304 0.215443469 0.6 1.1 0
305 0.3 0.6 1.1 0
}
sw sweep paramset=pts {
  tr tran stop=2n maxstep=1p errpreset=conservative outputstart=1.99n
}
