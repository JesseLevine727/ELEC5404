// Design: SAL45/STRONGARM_TB
simulator lang=spectre
global 0
parameters win=12u wtail=8u wrst=250n wlatn=1u wlatp=1u winvn=500n winvp=700n tper=2e-09 tpw=1.2e-09 trf=2e-11 tdel=2e-10 cl=5e-15 dvin=0.001 vcm=0.5 vdd=1.0
include "/CMC/kits/cadence/GPDK045/gpdk045_v_6_0/models/spectre/gpdk045.scs" section=tt

// SAL45/INV45/schematic
subckt INV45 IN OUT VDD VSS
    MP (OUT IN VDD VDD) g45p1lvt w=(winvp) l=45n nf=1 m=(1)
    MN (OUT IN VSS VSS) g45n1lvt w=(winvn) l=45n nf=1 m=(1)
ends INV45

// SAL45/STRONGARM/schematic
subckt STRONGARM CLK INN INP OUTN OUTP VDD VSS
    M4 (Y X Q VSS) g45n1lvt w=(wlatn) l=45n nf=1 m=(1)
    M3 (X Y P VSS) g45n1lvt w=(wlatn) l=45n nf=1 m=(1)
    M0 (TAIL CLK VSS VSS) g45n1lvt w=(wtail) l=45n nf=2 m=(1)
    M2 (Q INN TAIL VSS) g45n1lvt w=(win) l=45n nf=2 m=(1)
    M1 (P INP TAIL VSS) g45n1lvt w=(win) l=45n nf=2 m=(1)
    S4 (Q CLK VDD VDD) g45p1lvt w=(wrst) l=45n nf=1 m=(1)
    S3 (P CLK VDD VDD) g45p1lvt w=(wrst) l=45n nf=1 m=(1)
    S2 (Y CLK VDD VDD) g45p1lvt w=(wrst) l=45n nf=1 m=(1)
    S1 (X CLK VDD VDD) g45p1lvt w=(wrst) l=45n nf=1 m=(1)
    M6 (Y X VDD VDD) g45p1lvt w=(wlatp) l=45n nf=1 m=(1)
    M5 (X Y VDD VDD) g45p1lvt w=(wlatp) l=45n nf=1 m=(1)
    I_INVN (Y OUTN VDD VSS) INV45
    I_INVP (X OUTP VDD VSS) INV45
ends STRONGARM

// SAL45/STRONGARM_TB/schematic
I_SA (clk inn inp outn outp vdd 0) STRONGARM
VINN (inn 0) vsource dc=vcm-dvin/2 type=dc
VINP (inp 0) vsource dc=vcm+dvin/2 type=dc
V0 (vdd 0) vsource dc=vdd type=dc
VCLK (clk 0) vsource type=pulse val0=0 val1=vdd period=tper delay=tdel rise=trf fall=trf width=tpw
CLN (outn 0) capacitor c=cl
CLP (outp 0) capacitor c=cl
// ---- experiment 07_candidate
simOpts options reltol=1e-6 vabstol=1e-12 iabstol=1e-15 temp=27 tnom=27 save=selected
save outp outn clk V0:p

win_sw sweep param=win values=[12u] {
wtail_sw sweep param=wtail values=[8u] {
wrst_sw sweep param=wrst values=[250n] {
wlatn_sw sweep param=wlatn values=[1u 2u] {
wlatp_sw sweep param=wlatp values=[1u 2u] {
winvn_sw sweep param=winvn values=[500n 250n] {
winvp_sw sweep param=winvp values=[700n 1.4u] {
dv_sw sweep param=dvin values=[0.3 0.1 0.03 0.01 0.003 0.001 0.0001 1e-05 1e-06 1e-07 1e-08 1e-09] {
  tr tran stop=2n maxstep=1p errpreset=conservative
}
}
}
}
}
}
}
}
